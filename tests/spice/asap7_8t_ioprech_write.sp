* ASAP7 8T composite IO-column differential-write regression.
.param VDDVAL=0.7
VDD VDD 0 {VDDVAL}
VDA DA 0 {VDDVAL}
VDB DB 0 0
VSAE SAE 0 0
VOEB OEB 0 {VDDVAL}
VOE OE 0 0
VPRECH PRECH 0 PWL(0 0 0.55n 0 0.57n {VDDVAL} 2.4n {VDDVAL})
VSEL SEL 0 PWL(0 0 0.62n 0 0.64n {VDDVAL} 2.4n {VDDVAL})
VSELN SELN 0 PWL(0 {VDDVAL} 0.62n {VDDVAL} 0.64n 0 2.4n 0)
VWRENA_A WRENA_A 0 PWL(0 0 0.70n 0 0.72n {VDDVAL} 1.30n {VDDVAL} 1.32n 0 2.4n 0)
VWRENAN_A WRENAN_A 0 PWL(0 {VDDVAL} 0.70n {VDDVAL} 0.72n 0 1.30n 0 1.32n {VDDVAL} 2.4n {VDDVAL})
VWRENA_B WRENA_B 0 PWL(0 0 1.50n 0 1.52n {VDDVAL} 2.10n {VDDVAL} 2.12n 0 2.4n 0)
VWRENAN_B WRENAN_B 0 PWL(0 {VDDVAL} 1.50n {VDDVAL} 1.52n 0 2.10n 0 2.12n {VDDVAL} 2.4n {VDDVAL})
VOFFN OFFN 0 {VDDVAL}
VOFF OFF 0 0

.SUBCKT bitload4 N0 N1 N2 N3
C0 N0 0 10f
C1 N1 0 10f
C2 N2 0 10f
C3 N3 0 10f
R0 N0 0 1T
R1 N1 0 1T
R2 N2 0 1T
R3 N3 0 1T
.ENDS bitload4

XIO WRENA_A WRENAN_A WRENA_B WRENAN_B
+ OEB OE DA QA OEB OE DB QB
+ AT0 AT1 AT2 AT3 ATN0 ATN1 ATN2 ATN3
+ AB0 AB1 AB2 AB3 ABN0 ABN1 ABN2 ABN3
+ BT0 BT1 BT2 BT3 BTN0 BTN1 BTN2 BTN3
+ BB0 BB1 BB2 BB3 BBN0 BBN1 BBN2 BBN3
+ PRECH PRECH PRECH PRECH
+ SELN OFFN OFFN OFFN SEL OFF OFF OFF
+ SELN OFFN OFFN OFFN SEL OFF OFF OFF
+ SELN OFFN OFFN OFFN SEL OFF OFF OFF
+ SELN OFFN OFFN OFFN SEL OFF OFF OFF
+ SAE SAE VDD 0 iocolgrp_sram_8t

XATN ATN0 ATN1 ATN2 ATN3 bitload4
XAT AT0 AT1 AT2 AT3 bitload4
XABN ABN0 ABN1 ABN2 ABN3 bitload4
XAB AB0 AB1 AB2 AB3 bitload4
XBTN BTN0 BTN1 BTN2 BTN3 bitload4
XBT BT0 BT1 BT2 BT3 bitload4
XBBN BBN0 BBN1 BBN2 BBN3 bitload4
XBB BB0 BB1 BB2 BB3 bitload4

.ic V(ATN0)=0 V(AT0)=0 V(ABN0)=0 V(AB0)=0
+ V(BTN0)=0 V(BT0)=0 V(BBN0)=0 V(BB0)=0
.tran 1p 2.4n uic
.measure tran A_NEG_WRITE find V(ATN0) at=1.20n
.measure tran A_POS_WRITE find V(AT0) at=1.20n
.measure tran B_NEG_BEFORE_WRITE find V(BTN0) at=1.20n
.measure tran B_POS_BEFORE_WRITE find V(BT0) at=1.20n
.measure tran B_NEG_WRITE find V(BTN0) at=2.00n
.measure tran B_POS_WRITE find V(BT0) at=2.00n
.measure tran A_NEG_AFTER_B find V(ATN0) at=2.00n
.measure tran A_POS_AFTER_B find V(AT0) at=2.00n
.measure tran A_UNSEL_NEG find V(ATN1) at=1.20n
.measure tran A_UNSEL_POS find V(AT1) at=1.20n
.measure tran B_UNSEL_NEG find V(BTN1) at=2.00n
.measure tran B_UNSEL_POS find V(BT1) at=2.00n
.end
