* ASAP7 8T port-A/port-B wrapper precharge regression.
.param VDDVAL=0.7
VDD VDD 0 {VDDVAL}
VWRENAN WRENAN 0 {VDDVAL}
VWRENA WRENA 0 0
VSAE SAE 0 0
VSAPRECHN SAPRECHN 0 0
VOEB OEB 0 {VDDVAL}
VOE OE 0 0
VD D 0 0
VPT BLPRECHTN 0 PWL(0 0 0.60n 0 0.62n {VDDVAL} 1n {VDDVAL})
VPB BLPRECHBN 0 PWL(0 0 0.60n 0 0.62n {VDDVAL} 1n {VDDVAL})

* All four column-select transmission gates are off.
VYTN0 YTN0 0 {VDDVAL}
VYTN1 YTN1 0 {VDDVAL}
VYTN2 YTN2 0 {VDDVAL}
VYTN3 YTN3 0 {VDDVAL}
VYT0 YT0 0 0
VYT1 YT1 0 0
VYT2 YT2 0 0
VYT3 YT3 0 0
VYBN0 YBN0 0 {VDDVAL}
VYBN1 YBN1 0 {VDDVAL}
VYBN2 YBN2 0 {VDDVAL}
VYBN3 YBN3 0 {VDDVAL}
VYB0 YB0 0 0
VYB1 YB1 0 0
VYB2 YB2 0 0
VYB3 YB3 0 0

.SUBCKT bitload4 N0 N1 N2 N3
C0 N0 0 5f
C1 N1 0 5f
C2 N2 0 5f
C3 N3 0 5f
R0 N0 0 1T
R1 N1 0 1T
R2 N2 0 1T
R3 N3 0 1T
.ENDS bitload4

XIOA WRENAN WRENA SAE SAPRECHN OEB OE D QA
+ ATN0 ATN1 ATN2 ATN3 AT0 AT1 AT2 AT3
+ ABN0 ABN1 ABN2 ABN3 AB0 AB1 AB2 AB3
+ BLPRECHTN BLPRECHBN
+ YTN0 YTN1 YTN2 YTN3 YT0 YT1 YT2 YT3
+ YBN0 YBN1 YBN2 YBN3 YB0 YB1 YB2 YB3
+ VDD 0 ioprech_sram_8t_a

XIOB WRENAN WRENA SAE SAPRECHN OEB OE D QB
+ BTN0 BTN1 BTN2 BTN3 BT0 BT1 BT2 BT3
+ BBN0 BBN1 BBN2 BBN3 BB0 BB1 BB2 BB3
+ BLPRECHTN BLPRECHBN
+ YTN0 YTN1 YTN2 YTN3 YT0 YT1 YT2 YT3
+ YBN0 YBN1 YBN2 YBN3 YB0 YB1 YB2 YB3
+ VDD 0 ioprech_sram_8t_b

XATN ATN0 ATN1 ATN2 ATN3 bitload4
XAT AT0 AT1 AT2 AT3 bitload4
XABN ABN0 ABN1 ABN2 ABN3 bitload4
XAB AB0 AB1 AB2 AB3 bitload4
XBTN BTN0 BTN1 BTN2 BTN3 bitload4
XBT BT0 BT1 BT2 BT3 bitload4
XBBN BBN0 BBN1 BBN2 BBN3 bitload4
XBB BB0 BB1 BB2 BB3 bitload4

.ic V(ATN0)=0 V(AT0)=0 V(ABN0)=0 V(AB0)=0
+ V(BTN0)=0 V(BT0)=0 V(BBN0)=0 V(BB0)=0
.tran 1p 1n uic
.measure tran ATN0_PRE find V(ATN0) at=0.55n
.measure tran AT0_PRE find V(AT0) at=0.55n
.measure tran ABN0_PRE find V(ABN0) at=0.55n
.measure tran AB0_PRE find V(AB0) at=0.55n
.measure tran BTN0_PRE find V(BTN0) at=0.55n
.measure tran BT0_PRE find V(BT0) at=0.55n
.measure tran BBN0_PRE find V(BBN0) at=0.55n
.measure tran BB0_PRE find V(BB0) at=0.55n
.end
