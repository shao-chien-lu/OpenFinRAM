* ASAP7 8T port-A/port-B wrapper differential-read regression.
.param VDDVAL=0.7
VDD VDD 0 {VDDVAL}
VWRENAN WRENAN 0 {VDDVAL}
VWRENA WRENA 0 0
VD D 0 0
VOEB OEB 0 0
VOE OE 0 {VDDVAL}
VPRECH PRECH 0 PWL(0 0 0.60n 0 0.62n {VDDVAL} 2n {VDDVAL})
VSEL SEL 0 PWL(0 0 0.66n 0 0.68n {VDDVAL} 2n {VDDVAL})
VSELN SELN 0 PWL(0 {VDDVAL} 0.66n {VDDVAL} 0.68n 0 2n 0)
VSAE SAE 0 PWL(0 0 0.95n 0 0.97n {VDDVAL} 2n {VDDVAL})
VREAD READ 0 PWL(0 0 0.72n 0 0.74n {VDDVAL} 1.50n {VDDVAL} 1.52n 0 2n 0)
VOFFN OFFN 0 {VDDVAL}
VOFF OFF 0 0

.SUBCKT bitload4 N0 N1 N2 N3
C0 N0 0 10f
C1 N1 0 10f
C2 N2 0 10f
C3 N3 0 10f
R0 N0 0 1T
R1 N1 0 1T
R2 N2 0 1T
R3 N3 0 1T
.ENDS bitload4

* Port A sees the complement bitlines discharge (SAN < SA).
XIOA WRENAN WRENA SAE SAE OEB OE D QA
+ ATN0 ATN1 ATN2 ATN3 AT0 AT1 AT2 AT3
+ ABN0 ABN1 ABN2 ABN3 AB0 AB1 AB2 AB3
+ PRECH PRECH
+ SELN OFFN OFFN OFFN SEL OFF OFF OFF
+ SELN OFFN OFFN OFFN SEL OFF OFF OFF
+ VDD 0 ioprech_sram_8t_a

* Port B sees the true bitlines discharge (SA < SAN).
XIOB WRENAN WRENA SAE SAE OEB OE D QB
+ BTN0 BTN1 BTN2 BTN3 BT0 BT1 BT2 BT3
+ BBN0 BBN1 BBN2 BBN3 BB0 BB1 BB2 BB3
+ PRECH PRECH
+ SELN OFFN OFFN OFFN SEL OFF OFF OFF
+ SELN OFFN OFFN OFFN SEL OFF OFF OFF
+ VDD 0 ioprech_sram_8t_b

XATN ATN0 ATN1 ATN2 ATN3 bitload4
XAT AT0 AT1 AT2 AT3 bitload4
XABN ABN0 ABN1 ABN2 ABN3 bitload4
XAB AB0 AB1 AB2 AB3 bitload4
XBTN BTN0 BTN1 BTN2 BTN3 bitload4
XBT BT0 BT1 BT2 BT3 bitload4
XBBN BBN0 BBN1 BBN2 BBN3 bitload4
XBB BB0 BB1 BB2 BB3 bitload4

MAN0 ATN0 READ 0 0 nmos_rvt L=2e-08 nfin=2
MAN1 ABN0 READ 0 0 nmos_rvt L=2e-08 nfin=2
MBP0 BT0 READ 0 0 nmos_rvt L=2e-08 nfin=2
MBP1 BB0 READ 0 0 nmos_rvt L=2e-08 nfin=2

.ic V(ATN0)=0 V(AT0)=0 V(ABN0)=0 V(AB0)=0
+ V(BTN0)=0 V(BT0)=0 V(BBN0)=0 V(BB0)=0
.tran 1p 2n uic
.measure tran A_NEG_BEFORE_SA find V(ATN0) at=0.90n
.measure tran A_POS_BEFORE_SA find V(AT0) at=0.90n
.measure tran B_NEG_BEFORE_SA find V(BTN0) at=0.90n
.measure tran B_POS_BEFORE_SA find V(BT0) at=0.90n
.measure tran QA_READ find V(QA) at=1.40n
.measure tran QB_READ find V(QB) at=1.40n
.end
