* ASAP7 column IO, 270 nm leaves in one column: bitline mux, sense amplifier, write driver, output latch
.SUBCKT iocol_block_6t BL[0] BLN[0] YSEL[0] YSELN[0] BL[1] BLN[1] YSEL[1] YSELN[1] BL[2] BLN[2] YSEL[2] YSELN[2] BL[3] BLN[3] YSEL[3] YSELN[3] PRECHN SAE D WRENA WRENAN OE OEB Q VDD VSS
M0_NT BL[0] YSEL[0] SA VSS nmos_rvt nfin=3 l=20n nf=1 m=1
M0_NC BLN[0] YSEL[0] SAN VSS nmos_rvt nfin=3 l=20n nf=1 m=1
M0_PT SA YSELN[0] BL[0] VDD pmos_rvt nfin=3 l=20n nf=1 m=1
M0_PC SAN YSELN[0] BLN[0] VDD pmos_rvt nfin=3 l=20n nf=1 m=1
M0_PPT BL[0] PRECHN VDD VDD pmos_rvt nfin=3 l=20n nf=1 m=1
M0_PPC BLN[0] PRECHN VDD VDD pmos_rvt nfin=3 l=20n nf=1 m=1
M1_NT BL[1] YSEL[1] SA VSS nmos_rvt nfin=3 l=20n nf=1 m=1
M1_NC BLN[1] YSEL[1] SAN VSS nmos_rvt nfin=3 l=20n nf=1 m=1
M1_PT SA YSELN[1] BL[1] VDD pmos_rvt nfin=3 l=20n nf=1 m=1
M1_PC SAN YSELN[1] BLN[1] VDD pmos_rvt nfin=3 l=20n nf=1 m=1
M1_PPT BL[1] PRECHN VDD VDD pmos_rvt nfin=3 l=20n nf=1 m=1
M1_PPC BLN[1] PRECHN VDD VDD pmos_rvt nfin=3 l=20n nf=1 m=1
M2_NT BL[2] YSEL[2] SA VSS nmos_rvt nfin=3 l=20n nf=1 m=1
M2_NC BLN[2] YSEL[2] SAN VSS nmos_rvt nfin=3 l=20n nf=1 m=1
M2_PT SA YSELN[2] BL[2] VDD pmos_rvt nfin=3 l=20n nf=1 m=1
M2_PC SAN YSELN[2] BLN[2] VDD pmos_rvt nfin=3 l=20n nf=1 m=1
M2_PPT BL[2] PRECHN VDD VDD pmos_rvt nfin=3 l=20n nf=1 m=1
M2_PPC BLN[2] PRECHN VDD VDD pmos_rvt nfin=3 l=20n nf=1 m=1
M3_NT BL[3] YSEL[3] SA VSS nmos_rvt nfin=3 l=20n nf=1 m=1
M3_NC BLN[3] YSEL[3] SAN VSS nmos_rvt nfin=3 l=20n nf=1 m=1
M3_PT SA YSELN[3] BL[3] VDD pmos_rvt nfin=3 l=20n nf=1 m=1
M3_PC SAN YSELN[3] BLN[3] VDD pmos_rvt nfin=3 l=20n nf=1 m=1
M3_PPT BL[3] PRECHN VDD VDD pmos_rvt nfin=3 l=20n nf=1 m=1
M3_PPC BLN[3] PRECHN VDD VDD pmos_rvt nfin=3 l=20n nf=1 m=1
Msa_N6_0 sa_N57_0 SA sa_TAIL VSS nmos_rvt nfin=3 l=20n nf=1 m=1
Msa_N8_0 QAN QA sa_N57_0 VSS nmos_rvt nfin=3 l=20n nf=1 m=1
Msa_N7_0 sa_N58_0 SAN sa_TAIL VSS nmos_rvt nfin=3 l=20n nf=1 m=1
Msa_N9_0 QA QAN sa_N58_0 VSS nmos_rvt nfin=3 l=20n nf=1 m=1
Msa_P4_0 QAN QA VDD VDD pmos_rvt nfin=3 l=20n nf=1 m=1
Msa_P5_0 QA QAN VDD VDD pmos_rvt nfin=3 l=20n nf=1 m=1
Msa_N6_1 sa_N57_1 SA sa_TAIL VSS nmos_rvt nfin=3 l=20n nf=1 m=1
Msa_N8_1 QAN QA sa_N57_1 VSS nmos_rvt nfin=3 l=20n nf=1 m=1
Msa_N7_1 sa_N58_1 SAN sa_TAIL VSS nmos_rvt nfin=3 l=20n nf=1 m=1
Msa_N9_1 QA QAN sa_N58_1 VSS nmos_rvt nfin=3 l=20n nf=1 m=1
Msa_P4_1 QAN QA VDD VDD pmos_rvt nfin=3 l=20n nf=1 m=1
Msa_P5_1 QA QAN VDD VDD pmos_rvt nfin=3 l=20n nf=1 m=1
Msa_N10_0 sa_TAIL SAE VSS VSS nmos_rvt nfin=3 l=20n nf=1 m=1
Msa_N10_1 sa_TAIL SAE VSS VSS nmos_rvt nfin=3 l=20n nf=1 m=1
Msa_P0 QAN SAE VDD VDD pmos_rvt nfin=3 l=20n nf=1 m=1
Msa_P1 QAN SAE sa_N59 VDD pmos_rvt nfin=3 l=20n nf=1 m=1
Msa_P2 sa_N59 SAE QA VDD pmos_rvt nfin=3 l=20n nf=1 m=1
Msa_P3 QA SAE VDD VDD pmos_rvt nfin=3 l=20n nf=1 m=1
Mwd_NI wd_DN D VSS VSS nmos_rvt nfin=3 l=20n nf=1 m=1
Mwd_PI wd_DN D VDD VDD pmos_rvt nfin=3 l=20n nf=1 m=1
Mwd_NPD wd_W WRENAN D VSS nmos_rvt nfin=3 l=20n nf=1 m=1
Mwd_NPDN wd_WN WRENAN wd_DN VSS nmos_rvt nfin=3 l=20n nf=1 m=1
Mwd_NW wd_W wd_WN VSS VSS nmos_rvt nfin=3 l=20n nf=1 m=1
Mwd_NWN wd_WN wd_W VSS VSS nmos_rvt nfin=3 l=20n nf=1 m=1
Mwd_PW wd_W wd_WN VDD VDD pmos_rvt nfin=1 l=20n nf=1 m=1
Mwd_PWN wd_WN wd_W VDD VDD pmos_rvt nfin=1 l=20n nf=1 m=1
Mwd_NTW SA WRENA wd_W VSS nmos_rvt nfin=3 l=20n nf=1 m=1
Mwd_PTW SA WRENAN wd_W VDD pmos_rvt nfin=3 l=20n nf=1 m=1
Mwd_NTWN SAN WRENA wd_WN VSS nmos_rvt nfin=3 l=20n nf=1 m=1
Mwd_PTWN SAN WRENAN wd_WN VDD pmos_rvt nfin=3 l=20n nf=1 m=1
Mol_N1A ol_Y1 ol_Y2 ol_M1 VSS nmos_rvt nfin=3 l=20n nf=1 m=1
Mol_N1B ol_M1 QA VSS VSS nmos_rvt nfin=3 l=20n nf=1 m=1
Mol_P1A ol_Y1 ol_Y2 VDD VDD pmos_rvt nfin=3 l=20n nf=1 m=1
Mol_P1B ol_Y1 QA VDD VDD pmos_rvt nfin=3 l=20n nf=1 m=1
Mol_N2A ol_Y2 QAN ol_M2 VSS nmos_rvt nfin=3 l=20n nf=1 m=1
Mol_N2B ol_M2 ol_Y1 VSS VSS nmos_rvt nfin=3 l=20n nf=1 m=1
Mol_P2A ol_Y2 QAN VDD VDD pmos_rvt nfin=3 l=20n nf=1 m=1
Mol_P2B ol_Y2 ol_Y1 VDD VDD pmos_rvt nfin=3 l=20n nf=1 m=1
Mol_NI0 ol_Y2N ol_Y2 VSS VSS nmos_rvt nfin=3 l=20n nf=1 m=1
Mol_NI1 ol_Y2N ol_Y2 VSS VSS nmos_rvt nfin=3 l=20n nf=1 m=1
Mol_PI0 ol_Y2N ol_Y2 VDD VDD pmos_rvt nfin=3 l=20n nf=1 m=1
Mol_PI1 ol_Y2N ol_Y2 VDD VDD pmos_rvt nfin=3 l=20n nf=1 m=1
Mol_NA ol_N2 ol_Y2N VSS VSS nmos_rvt nfin=3 l=20n nf=1 m=1
Mol_NE Q OE ol_N2 VSS nmos_rvt nfin=3 l=20n nf=1 m=1
Mol_PA ol_N1 ol_Y2N VDD VDD pmos_rvt nfin=3 l=20n nf=1 m=1
Mol_PE Q OEB ol_N1 VDD pmos_rvt nfin=3 l=20n nf=1 m=1
.ENDS iocol_block_6t
.SUBCKT iocol_sram_6t BL_A[0] BLN_A[0] yselA[0] yselnA[0] BL_A[1] BLN_A[1] yselA[1] yselnA[1] BL_A[2] BLN_A[2] yselA[2] yselnA[2] BL_A[3] BLN_A[3] yselA[3] yselnA[3] blprechnA sae_A DA wrenaA wrenanA oe_outA oeb_outA QA VDD VSS
X_block BL_A[0] BLN_A[0] yselA[0] yselnA[0] BL_A[1] BLN_A[1] yselA[1] yselnA[1] BL_A[2] BLN_A[2] yselA[2] yselnA[2] BL_A[3] BLN_A[3] yselA[3] yselnA[3] blprechnA sae_A DA wrenaA wrenanA oe_outA oeb_outA QA VDD VSS iocol_block_6t
.ENDS iocol_sram_6t
* ASAP7 column IO, 270 nm leaves in one column: bitline mux, sense amplifier, write driver, output latch
.SUBCKT iocol_block_6t_x8 BL[0] BLN[0] YSELN[0] BL[1] BLN[1] YSELN[1] BL[2] BLN[2] YSELN[2] BL[3] BLN[3] YSELN[3] BL[4] BLN[4] YSELN[4] BL[5] BLN[5] YSELN[5] BL[6] BLN[6] YSELN[6] BL[7] BLN[7] YSELN[7] PRECHN SAE D WRENA WRENAN OE OEB Q VDD VSS
M0_NI YSEL[0] YSELN[0] VSS VSS nmos_rvt nfin=3 l=20n nf=1 m=1
M0_PI YSEL[0] YSELN[0] VDD VDD pmos_rvt nfin=3 l=20n nf=1 m=1
M0_NT BL[0] YSEL[0] SA VSS nmos_rvt nfin=3 l=20n nf=1 m=1
M0_NC BLN[0] YSEL[0] SAN VSS nmos_rvt nfin=3 l=20n nf=1 m=1
M0_PT SA YSELN[0] BL[0] VDD pmos_rvt nfin=3 l=20n nf=1 m=1
M0_PC SAN YSELN[0] BLN[0] VDD pmos_rvt nfin=3 l=20n nf=1 m=1
M0_PPT BL[0] PRECHN VDD VDD pmos_rvt nfin=3 l=20n nf=1 m=1
M0_PPC BLN[0] PRECHN VDD VDD pmos_rvt nfin=3 l=20n nf=1 m=1
M1_NI YSEL[1] YSELN[1] VSS VSS nmos_rvt nfin=3 l=20n nf=1 m=1
M1_PI YSEL[1] YSELN[1] VDD VDD pmos_rvt nfin=3 l=20n nf=1 m=1
M1_NT BL[1] YSEL[1] SA VSS nmos_rvt nfin=3 l=20n nf=1 m=1
M1_NC BLN[1] YSEL[1] SAN VSS nmos_rvt nfin=3 l=20n nf=1 m=1
M1_PT SA YSELN[1] BL[1] VDD pmos_rvt nfin=3 l=20n nf=1 m=1
M1_PC SAN YSELN[1] BLN[1] VDD pmos_rvt nfin=3 l=20n nf=1 m=1
M1_PPT BL[1] PRECHN VDD VDD pmos_rvt nfin=3 l=20n nf=1 m=1
M1_PPC BLN[1] PRECHN VDD VDD pmos_rvt nfin=3 l=20n nf=1 m=1
M2_NI YSEL[2] YSELN[2] VSS VSS nmos_rvt nfin=3 l=20n nf=1 m=1
M2_PI YSEL[2] YSELN[2] VDD VDD pmos_rvt nfin=3 l=20n nf=1 m=1
M2_NT BL[2] YSEL[2] SA VSS nmos_rvt nfin=3 l=20n nf=1 m=1
M2_NC BLN[2] YSEL[2] SAN VSS nmos_rvt nfin=3 l=20n nf=1 m=1
M2_PT SA YSELN[2] BL[2] VDD pmos_rvt nfin=3 l=20n nf=1 m=1
M2_PC SAN YSELN[2] BLN[2] VDD pmos_rvt nfin=3 l=20n nf=1 m=1
M2_PPT BL[2] PRECHN VDD VDD pmos_rvt nfin=3 l=20n nf=1 m=1
M2_PPC BLN[2] PRECHN VDD VDD pmos_rvt nfin=3 l=20n nf=1 m=1
M3_NI YSEL[3] YSELN[3] VSS VSS nmos_rvt nfin=3 l=20n nf=1 m=1
M3_PI YSEL[3] YSELN[3] VDD VDD pmos_rvt nfin=3 l=20n nf=1 m=1
M3_NT BL[3] YSEL[3] SA VSS nmos_rvt nfin=3 l=20n nf=1 m=1
M3_NC BLN[3] YSEL[3] SAN VSS nmos_rvt nfin=3 l=20n nf=1 m=1
M3_PT SA YSELN[3] BL[3] VDD pmos_rvt nfin=3 l=20n nf=1 m=1
M3_PC SAN YSELN[3] BLN[3] VDD pmos_rvt nfin=3 l=20n nf=1 m=1
M3_PPT BL[3] PRECHN VDD VDD pmos_rvt nfin=3 l=20n nf=1 m=1
M3_PPC BLN[3] PRECHN VDD VDD pmos_rvt nfin=3 l=20n nf=1 m=1
M4_NI YSEL[4] YSELN[4] VSS VSS nmos_rvt nfin=3 l=20n nf=1 m=1
M4_PI YSEL[4] YSELN[4] VDD VDD pmos_rvt nfin=3 l=20n nf=1 m=1
M4_NT BL[4] YSEL[4] SA VSS nmos_rvt nfin=3 l=20n nf=1 m=1
M4_NC BLN[4] YSEL[4] SAN VSS nmos_rvt nfin=3 l=20n nf=1 m=1
M4_PT SA YSELN[4] BL[4] VDD pmos_rvt nfin=3 l=20n nf=1 m=1
M4_PC SAN YSELN[4] BLN[4] VDD pmos_rvt nfin=3 l=20n nf=1 m=1
M4_PPT BL[4] PRECHN VDD VDD pmos_rvt nfin=3 l=20n nf=1 m=1
M4_PPC BLN[4] PRECHN VDD VDD pmos_rvt nfin=3 l=20n nf=1 m=1
M5_NI YSEL[5] YSELN[5] VSS VSS nmos_rvt nfin=3 l=20n nf=1 m=1
M5_PI YSEL[5] YSELN[5] VDD VDD pmos_rvt nfin=3 l=20n nf=1 m=1
M5_NT BL[5] YSEL[5] SA VSS nmos_rvt nfin=3 l=20n nf=1 m=1
M5_NC BLN[5] YSEL[5] SAN VSS nmos_rvt nfin=3 l=20n nf=1 m=1
M5_PT SA YSELN[5] BL[5] VDD pmos_rvt nfin=3 l=20n nf=1 m=1
M5_PC SAN YSELN[5] BLN[5] VDD pmos_rvt nfin=3 l=20n nf=1 m=1
M5_PPT BL[5] PRECHN VDD VDD pmos_rvt nfin=3 l=20n nf=1 m=1
M5_PPC BLN[5] PRECHN VDD VDD pmos_rvt nfin=3 l=20n nf=1 m=1
M6_NI YSEL[6] YSELN[6] VSS VSS nmos_rvt nfin=3 l=20n nf=1 m=1
M6_PI YSEL[6] YSELN[6] VDD VDD pmos_rvt nfin=3 l=20n nf=1 m=1
M6_NT BL[6] YSEL[6] SA VSS nmos_rvt nfin=3 l=20n nf=1 m=1
M6_NC BLN[6] YSEL[6] SAN VSS nmos_rvt nfin=3 l=20n nf=1 m=1
M6_PT SA YSELN[6] BL[6] VDD pmos_rvt nfin=3 l=20n nf=1 m=1
M6_PC SAN YSELN[6] BLN[6] VDD pmos_rvt nfin=3 l=20n nf=1 m=1
M6_PPT BL[6] PRECHN VDD VDD pmos_rvt nfin=3 l=20n nf=1 m=1
M6_PPC BLN[6] PRECHN VDD VDD pmos_rvt nfin=3 l=20n nf=1 m=1
M7_NI YSEL[7] YSELN[7] VSS VSS nmos_rvt nfin=3 l=20n nf=1 m=1
M7_PI YSEL[7] YSELN[7] VDD VDD pmos_rvt nfin=3 l=20n nf=1 m=1
M7_NT BL[7] YSEL[7] SA VSS nmos_rvt nfin=3 l=20n nf=1 m=1
M7_NC BLN[7] YSEL[7] SAN VSS nmos_rvt nfin=3 l=20n nf=1 m=1
M7_PT SA YSELN[7] BL[7] VDD pmos_rvt nfin=3 l=20n nf=1 m=1
M7_PC SAN YSELN[7] BLN[7] VDD pmos_rvt nfin=3 l=20n nf=1 m=1
M7_PPT BL[7] PRECHN VDD VDD pmos_rvt nfin=3 l=20n nf=1 m=1
M7_PPC BLN[7] PRECHN VDD VDD pmos_rvt nfin=3 l=20n nf=1 m=1
Msa_N6_0 sa_N57_0 SA sa_TAIL VSS nmos_rvt nfin=3 l=20n nf=1 m=1
Msa_N8_0 QAN QA sa_N57_0 VSS nmos_rvt nfin=3 l=20n nf=1 m=1
Msa_N7_0 sa_N58_0 SAN sa_TAIL VSS nmos_rvt nfin=3 l=20n nf=1 m=1
Msa_N9_0 QA QAN sa_N58_0 VSS nmos_rvt nfin=3 l=20n nf=1 m=1
Msa_P4_0 QAN QA VDD VDD pmos_rvt nfin=3 l=20n nf=1 m=1
Msa_P5_0 QA QAN VDD VDD pmos_rvt nfin=3 l=20n nf=1 m=1
Msa_N6_1 sa_N57_1 SA sa_TAIL VSS nmos_rvt nfin=3 l=20n nf=1 m=1
Msa_N8_1 QAN QA sa_N57_1 VSS nmos_rvt nfin=3 l=20n nf=1 m=1
Msa_N7_1 sa_N58_1 SAN sa_TAIL VSS nmos_rvt nfin=3 l=20n nf=1 m=1
Msa_N9_1 QA QAN sa_N58_1 VSS nmos_rvt nfin=3 l=20n nf=1 m=1
Msa_P4_1 QAN QA VDD VDD pmos_rvt nfin=3 l=20n nf=1 m=1
Msa_P5_1 QA QAN VDD VDD pmos_rvt nfin=3 l=20n nf=1 m=1
Msa_N10_0 sa_TAIL SAE VSS VSS nmos_rvt nfin=3 l=20n nf=1 m=1
Msa_N10_1 sa_TAIL SAE VSS VSS nmos_rvt nfin=3 l=20n nf=1 m=1
Msa_P0 QAN SAE VDD VDD pmos_rvt nfin=3 l=20n nf=1 m=1
Msa_P1 QAN SAE sa_N59 VDD pmos_rvt nfin=3 l=20n nf=1 m=1
Msa_P2 sa_N59 SAE QA VDD pmos_rvt nfin=3 l=20n nf=1 m=1
Msa_P3 QA SAE VDD VDD pmos_rvt nfin=3 l=20n nf=1 m=1
Mwd_NI wd_DN D VSS VSS nmos_rvt nfin=3 l=20n nf=1 m=1
Mwd_PI wd_DN D VDD VDD pmos_rvt nfin=3 l=20n nf=1 m=1
Mwd_NPD wd_W WRENAN D VSS nmos_rvt nfin=3 l=20n nf=1 m=1
Mwd_NPDN wd_WN WRENAN wd_DN VSS nmos_rvt nfin=3 l=20n nf=1 m=1
Mwd_NW wd_W wd_WN VSS VSS nmos_rvt nfin=3 l=20n nf=1 m=1
Mwd_NWN wd_WN wd_W VSS VSS nmos_rvt nfin=3 l=20n nf=1 m=1
Mwd_PW wd_W wd_WN VDD VDD pmos_rvt nfin=1 l=20n nf=1 m=1
Mwd_PWN wd_WN wd_W VDD VDD pmos_rvt nfin=1 l=20n nf=1 m=1
Mwd_NTW SA WRENA wd_W VSS nmos_rvt nfin=3 l=20n nf=1 m=1
Mwd_PTW SA WRENAN wd_W VDD pmos_rvt nfin=3 l=20n nf=1 m=1
Mwd_NTWN SAN WRENA wd_WN VSS nmos_rvt nfin=3 l=20n nf=1 m=1
Mwd_PTWN SAN WRENAN wd_WN VDD pmos_rvt nfin=3 l=20n nf=1 m=1
Mol_N1A ol_Y1 ol_Y2 ol_M1 VSS nmos_rvt nfin=3 l=20n nf=1 m=1
Mol_N1B ol_M1 QA VSS VSS nmos_rvt nfin=3 l=20n nf=1 m=1
Mol_P1A ol_Y1 ol_Y2 VDD VDD pmos_rvt nfin=3 l=20n nf=1 m=1
Mol_P1B ol_Y1 QA VDD VDD pmos_rvt nfin=3 l=20n nf=1 m=1
Mol_N2A ol_Y2 QAN ol_M2 VSS nmos_rvt nfin=3 l=20n nf=1 m=1
Mol_N2B ol_M2 ol_Y1 VSS VSS nmos_rvt nfin=3 l=20n nf=1 m=1
Mol_P2A ol_Y2 QAN VDD VDD pmos_rvt nfin=3 l=20n nf=1 m=1
Mol_P2B ol_Y2 ol_Y1 VDD VDD pmos_rvt nfin=3 l=20n nf=1 m=1
Mol_NI0 ol_Y2N ol_Y2 VSS VSS nmos_rvt nfin=3 l=20n nf=1 m=1
Mol_NI1 ol_Y2N ol_Y2 VSS VSS nmos_rvt nfin=3 l=20n nf=1 m=1
Mol_PI0 ol_Y2N ol_Y2 VDD VDD pmos_rvt nfin=3 l=20n nf=1 m=1
Mol_PI1 ol_Y2N ol_Y2 VDD VDD pmos_rvt nfin=3 l=20n nf=1 m=1
Mol_NA ol_N2 ol_Y2N VSS VSS nmos_rvt nfin=3 l=20n nf=1 m=1
Mol_NE Q OE ol_N2 VSS nmos_rvt nfin=3 l=20n nf=1 m=1
Mol_PA ol_N1 ol_Y2N VDD VDD pmos_rvt nfin=3 l=20n nf=1 m=1
Mol_PE Q OEB ol_N1 VDD pmos_rvt nfin=3 l=20n nf=1 m=1
.ENDS iocol_block_6t_x8
.SUBCKT iocol_sram_6t_x8 BL_A[0] BLN_A[0] yselnA[0] BL_A[1] BLN_A[1] yselnA[1] BL_A[2] BLN_A[2] yselnA[2] BL_A[3] BLN_A[3] yselnA[3] BL_A[4] BLN_A[4] yselnA[4] BL_A[5] BLN_A[5] yselnA[5] BL_A[6] BLN_A[6] yselnA[6] BL_A[7] BLN_A[7] yselnA[7] blprechnA sae_A DA wrenaA wrenanA oe_outA oeb_outA QA VDD VSS
X_block BL_A[0] BLN_A[0] yselnA[0] BL_A[1] BLN_A[1] yselnA[1] BL_A[2] BLN_A[2] yselnA[2] BL_A[3] BLN_A[3] yselnA[3] BL_A[4] BLN_A[4] yselnA[4] BL_A[5] BLN_A[5] yselnA[5] BL_A[6] BLN_A[6] yselnA[6] BL_A[7] BLN_A[7] yselnA[7] blprechnA sae_A DA wrenaA wrenanA oe_outA oeb_outA QA VDD VSS iocol_block_6t_x8
.ENDS iocol_sram_6t_x8
* ASAP7 column IO, 270 nm leaves in one column: bitline mux, sense amplifier, write driver, output latch
.SUBCKT iocol_block_6t_x16 BL[0] BLN[0] BL[1] BLN[1] BL[2] BLN[2] BL[3] BLN[3] BL[4] BLN[4] BL[5] BLN[5] BL[6] BLN[6] BL[7] BLN[7] BL[8] BLN[8] BL[9] BLN[9] BL[10] BLN[10] BL[11] BLN[11] BL[12] BLN[12] BL[13] BLN[13] BL[14] BLN[14] BL[15] BLN[15] YPA[0] YPA[1] YPA[2] YPA[3] YPB[0] YPB[1] YPB[2] YPB[3] PRECHN SAE D WRENA WRENAN OE OEB Q VDD VSS
M0_NA YSELN[0] YPA[0] YN[0] VSS nmos_rvt nfin=3 l=20n nf=1 m=1
M0_NB YN[0] YPB[0] VSS VSS nmos_rvt nfin=3 l=20n nf=1 m=1
M0_PA YSELN[0] YPA[0] VDD VDD pmos_rvt nfin=3 l=20n nf=1 m=1
M0_PB YSELN[0] YPB[0] VDD VDD pmos_rvt nfin=3 l=20n nf=1 m=1
M0_NI YSEL[0] YSELN[0] VSS VSS nmos_rvt nfin=3 l=20n nf=1 m=1
M0_PI YSEL[0] YSELN[0] VDD VDD pmos_rvt nfin=3 l=20n nf=1 m=1
M0_NT BL[0] YSEL[0] SA VSS nmos_rvt nfin=3 l=20n nf=1 m=1
M0_NC BLN[0] YSEL[0] SAN VSS nmos_rvt nfin=3 l=20n nf=1 m=1
M0_PT SA YSELN[0] BL[0] VDD pmos_rvt nfin=3 l=20n nf=1 m=1
M0_PC SAN YSELN[0] BLN[0] VDD pmos_rvt nfin=3 l=20n nf=1 m=1
M0_PPT BL[0] PRECHN VDD VDD pmos_rvt nfin=3 l=20n nf=1 m=1
M0_PPC BLN[0] PRECHN VDD VDD pmos_rvt nfin=3 l=20n nf=1 m=1
M1_NA YSELN[1] YPA[1] YN[1] VSS nmos_rvt nfin=3 l=20n nf=1 m=1
M1_NB YN[1] YPB[0] VSS VSS nmos_rvt nfin=3 l=20n nf=1 m=1
M1_PA YSELN[1] YPA[1] VDD VDD pmos_rvt nfin=3 l=20n nf=1 m=1
M1_PB YSELN[1] YPB[0] VDD VDD pmos_rvt nfin=3 l=20n nf=1 m=1
M1_NI YSEL[1] YSELN[1] VSS VSS nmos_rvt nfin=3 l=20n nf=1 m=1
M1_PI YSEL[1] YSELN[1] VDD VDD pmos_rvt nfin=3 l=20n nf=1 m=1
M1_NT BL[1] YSEL[1] SA VSS nmos_rvt nfin=3 l=20n nf=1 m=1
M1_NC BLN[1] YSEL[1] SAN VSS nmos_rvt nfin=3 l=20n nf=1 m=1
M1_PT SA YSELN[1] BL[1] VDD pmos_rvt nfin=3 l=20n nf=1 m=1
M1_PC SAN YSELN[1] BLN[1] VDD pmos_rvt nfin=3 l=20n nf=1 m=1
M1_PPT BL[1] PRECHN VDD VDD pmos_rvt nfin=3 l=20n nf=1 m=1
M1_PPC BLN[1] PRECHN VDD VDD pmos_rvt nfin=3 l=20n nf=1 m=1
M2_NA YSELN[2] YPA[2] YN[2] VSS nmos_rvt nfin=3 l=20n nf=1 m=1
M2_NB YN[2] YPB[0] VSS VSS nmos_rvt nfin=3 l=20n nf=1 m=1
M2_PA YSELN[2] YPA[2] VDD VDD pmos_rvt nfin=3 l=20n nf=1 m=1
M2_PB YSELN[2] YPB[0] VDD VDD pmos_rvt nfin=3 l=20n nf=1 m=1
M2_NI YSEL[2] YSELN[2] VSS VSS nmos_rvt nfin=3 l=20n nf=1 m=1
M2_PI YSEL[2] YSELN[2] VDD VDD pmos_rvt nfin=3 l=20n nf=1 m=1
M2_NT BL[2] YSEL[2] SA VSS nmos_rvt nfin=3 l=20n nf=1 m=1
M2_NC BLN[2] YSEL[2] SAN VSS nmos_rvt nfin=3 l=20n nf=1 m=1
M2_PT SA YSELN[2] BL[2] VDD pmos_rvt nfin=3 l=20n nf=1 m=1
M2_PC SAN YSELN[2] BLN[2] VDD pmos_rvt nfin=3 l=20n nf=1 m=1
M2_PPT BL[2] PRECHN VDD VDD pmos_rvt nfin=3 l=20n nf=1 m=1
M2_PPC BLN[2] PRECHN VDD VDD pmos_rvt nfin=3 l=20n nf=1 m=1
M3_NA YSELN[3] YPA[3] YN[3] VSS nmos_rvt nfin=3 l=20n nf=1 m=1
M3_NB YN[3] YPB[0] VSS VSS nmos_rvt nfin=3 l=20n nf=1 m=1
M3_PA YSELN[3] YPA[3] VDD VDD pmos_rvt nfin=3 l=20n nf=1 m=1
M3_PB YSELN[3] YPB[0] VDD VDD pmos_rvt nfin=3 l=20n nf=1 m=1
M3_NI YSEL[3] YSELN[3] VSS VSS nmos_rvt nfin=3 l=20n nf=1 m=1
M3_PI YSEL[3] YSELN[3] VDD VDD pmos_rvt nfin=3 l=20n nf=1 m=1
M3_NT BL[3] YSEL[3] SA VSS nmos_rvt nfin=3 l=20n nf=1 m=1
M3_NC BLN[3] YSEL[3] SAN VSS nmos_rvt nfin=3 l=20n nf=1 m=1
M3_PT SA YSELN[3] BL[3] VDD pmos_rvt nfin=3 l=20n nf=1 m=1
M3_PC SAN YSELN[3] BLN[3] VDD pmos_rvt nfin=3 l=20n nf=1 m=1
M3_PPT BL[3] PRECHN VDD VDD pmos_rvt nfin=3 l=20n nf=1 m=1
M3_PPC BLN[3] PRECHN VDD VDD pmos_rvt nfin=3 l=20n nf=1 m=1
M4_NA YSELN[4] YPA[0] YN[4] VSS nmos_rvt nfin=3 l=20n nf=1 m=1
M4_NB YN[4] YPB[1] VSS VSS nmos_rvt nfin=3 l=20n nf=1 m=1
M4_PA YSELN[4] YPA[0] VDD VDD pmos_rvt nfin=3 l=20n nf=1 m=1
M4_PB YSELN[4] YPB[1] VDD VDD pmos_rvt nfin=3 l=20n nf=1 m=1
M4_NI YSEL[4] YSELN[4] VSS VSS nmos_rvt nfin=3 l=20n nf=1 m=1
M4_PI YSEL[4] YSELN[4] VDD VDD pmos_rvt nfin=3 l=20n nf=1 m=1
M4_NT BL[4] YSEL[4] SA VSS nmos_rvt nfin=3 l=20n nf=1 m=1
M4_NC BLN[4] YSEL[4] SAN VSS nmos_rvt nfin=3 l=20n nf=1 m=1
M4_PT SA YSELN[4] BL[4] VDD pmos_rvt nfin=3 l=20n nf=1 m=1
M4_PC SAN YSELN[4] BLN[4] VDD pmos_rvt nfin=3 l=20n nf=1 m=1
M4_PPT BL[4] PRECHN VDD VDD pmos_rvt nfin=3 l=20n nf=1 m=1
M4_PPC BLN[4] PRECHN VDD VDD pmos_rvt nfin=3 l=20n nf=1 m=1
M5_NA YSELN[5] YPA[1] YN[5] VSS nmos_rvt nfin=3 l=20n nf=1 m=1
M5_NB YN[5] YPB[1] VSS VSS nmos_rvt nfin=3 l=20n nf=1 m=1
M5_PA YSELN[5] YPA[1] VDD VDD pmos_rvt nfin=3 l=20n nf=1 m=1
M5_PB YSELN[5] YPB[1] VDD VDD pmos_rvt nfin=3 l=20n nf=1 m=1
M5_NI YSEL[5] YSELN[5] VSS VSS nmos_rvt nfin=3 l=20n nf=1 m=1
M5_PI YSEL[5] YSELN[5] VDD VDD pmos_rvt nfin=3 l=20n nf=1 m=1
M5_NT BL[5] YSEL[5] SA VSS nmos_rvt nfin=3 l=20n nf=1 m=1
M5_NC BLN[5] YSEL[5] SAN VSS nmos_rvt nfin=3 l=20n nf=1 m=1
M5_PT SA YSELN[5] BL[5] VDD pmos_rvt nfin=3 l=20n nf=1 m=1
M5_PC SAN YSELN[5] BLN[5] VDD pmos_rvt nfin=3 l=20n nf=1 m=1
M5_PPT BL[5] PRECHN VDD VDD pmos_rvt nfin=3 l=20n nf=1 m=1
M5_PPC BLN[5] PRECHN VDD VDD pmos_rvt nfin=3 l=20n nf=1 m=1
M6_NA YSELN[6] YPA[2] YN[6] VSS nmos_rvt nfin=3 l=20n nf=1 m=1
M6_NB YN[6] YPB[1] VSS VSS nmos_rvt nfin=3 l=20n nf=1 m=1
M6_PA YSELN[6] YPA[2] VDD VDD pmos_rvt nfin=3 l=20n nf=1 m=1
M6_PB YSELN[6] YPB[1] VDD VDD pmos_rvt nfin=3 l=20n nf=1 m=1
M6_NI YSEL[6] YSELN[6] VSS VSS nmos_rvt nfin=3 l=20n nf=1 m=1
M6_PI YSEL[6] YSELN[6] VDD VDD pmos_rvt nfin=3 l=20n nf=1 m=1
M6_NT BL[6] YSEL[6] SA VSS nmos_rvt nfin=3 l=20n nf=1 m=1
M6_NC BLN[6] YSEL[6] SAN VSS nmos_rvt nfin=3 l=20n nf=1 m=1
M6_PT SA YSELN[6] BL[6] VDD pmos_rvt nfin=3 l=20n nf=1 m=1
M6_PC SAN YSELN[6] BLN[6] VDD pmos_rvt nfin=3 l=20n nf=1 m=1
M6_PPT BL[6] PRECHN VDD VDD pmos_rvt nfin=3 l=20n nf=1 m=1
M6_PPC BLN[6] PRECHN VDD VDD pmos_rvt nfin=3 l=20n nf=1 m=1
M7_NA YSELN[7] YPA[3] YN[7] VSS nmos_rvt nfin=3 l=20n nf=1 m=1
M7_NB YN[7] YPB[1] VSS VSS nmos_rvt nfin=3 l=20n nf=1 m=1
M7_PA YSELN[7] YPA[3] VDD VDD pmos_rvt nfin=3 l=20n nf=1 m=1
M7_PB YSELN[7] YPB[1] VDD VDD pmos_rvt nfin=3 l=20n nf=1 m=1
M7_NI YSEL[7] YSELN[7] VSS VSS nmos_rvt nfin=3 l=20n nf=1 m=1
M7_PI YSEL[7] YSELN[7] VDD VDD pmos_rvt nfin=3 l=20n nf=1 m=1
M7_NT BL[7] YSEL[7] SA VSS nmos_rvt nfin=3 l=20n nf=1 m=1
M7_NC BLN[7] YSEL[7] SAN VSS nmos_rvt nfin=3 l=20n nf=1 m=1
M7_PT SA YSELN[7] BL[7] VDD pmos_rvt nfin=3 l=20n nf=1 m=1
M7_PC SAN YSELN[7] BLN[7] VDD pmos_rvt nfin=3 l=20n nf=1 m=1
M7_PPT BL[7] PRECHN VDD VDD pmos_rvt nfin=3 l=20n nf=1 m=1
M7_PPC BLN[7] PRECHN VDD VDD pmos_rvt nfin=3 l=20n nf=1 m=1
M8_NA YSELN[8] YPA[0] YN[8] VSS nmos_rvt nfin=3 l=20n nf=1 m=1
M8_NB YN[8] YPB[2] VSS VSS nmos_rvt nfin=3 l=20n nf=1 m=1
M8_PA YSELN[8] YPA[0] VDD VDD pmos_rvt nfin=3 l=20n nf=1 m=1
M8_PB YSELN[8] YPB[2] VDD VDD pmos_rvt nfin=3 l=20n nf=1 m=1
M8_NI YSEL[8] YSELN[8] VSS VSS nmos_rvt nfin=3 l=20n nf=1 m=1
M8_PI YSEL[8] YSELN[8] VDD VDD pmos_rvt nfin=3 l=20n nf=1 m=1
M8_NT BL[8] YSEL[8] SA VSS nmos_rvt nfin=3 l=20n nf=1 m=1
M8_NC BLN[8] YSEL[8] SAN VSS nmos_rvt nfin=3 l=20n nf=1 m=1
M8_PT SA YSELN[8] BL[8] VDD pmos_rvt nfin=3 l=20n nf=1 m=1
M8_PC SAN YSELN[8] BLN[8] VDD pmos_rvt nfin=3 l=20n nf=1 m=1
M8_PPT BL[8] PRECHN VDD VDD pmos_rvt nfin=3 l=20n nf=1 m=1
M8_PPC BLN[8] PRECHN VDD VDD pmos_rvt nfin=3 l=20n nf=1 m=1
M9_NA YSELN[9] YPA[1] YN[9] VSS nmos_rvt nfin=3 l=20n nf=1 m=1
M9_NB YN[9] YPB[2] VSS VSS nmos_rvt nfin=3 l=20n nf=1 m=1
M9_PA YSELN[9] YPA[1] VDD VDD pmos_rvt nfin=3 l=20n nf=1 m=1
M9_PB YSELN[9] YPB[2] VDD VDD pmos_rvt nfin=3 l=20n nf=1 m=1
M9_NI YSEL[9] YSELN[9] VSS VSS nmos_rvt nfin=3 l=20n nf=1 m=1
M9_PI YSEL[9] YSELN[9] VDD VDD pmos_rvt nfin=3 l=20n nf=1 m=1
M9_NT BL[9] YSEL[9] SA VSS nmos_rvt nfin=3 l=20n nf=1 m=1
M9_NC BLN[9] YSEL[9] SAN VSS nmos_rvt nfin=3 l=20n nf=1 m=1
M9_PT SA YSELN[9] BL[9] VDD pmos_rvt nfin=3 l=20n nf=1 m=1
M9_PC SAN YSELN[9] BLN[9] VDD pmos_rvt nfin=3 l=20n nf=1 m=1
M9_PPT BL[9] PRECHN VDD VDD pmos_rvt nfin=3 l=20n nf=1 m=1
M9_PPC BLN[9] PRECHN VDD VDD pmos_rvt nfin=3 l=20n nf=1 m=1
M10_NA YSELN[10] YPA[2] YN[10] VSS nmos_rvt nfin=3 l=20n nf=1 m=1
M10_NB YN[10] YPB[2] VSS VSS nmos_rvt nfin=3 l=20n nf=1 m=1
M10_PA YSELN[10] YPA[2] VDD VDD pmos_rvt nfin=3 l=20n nf=1 m=1
M10_PB YSELN[10] YPB[2] VDD VDD pmos_rvt nfin=3 l=20n nf=1 m=1
M10_NI YSEL[10] YSELN[10] VSS VSS nmos_rvt nfin=3 l=20n nf=1 m=1
M10_PI YSEL[10] YSELN[10] VDD VDD pmos_rvt nfin=3 l=20n nf=1 m=1
M10_NT BL[10] YSEL[10] SA VSS nmos_rvt nfin=3 l=20n nf=1 m=1
M10_NC BLN[10] YSEL[10] SAN VSS nmos_rvt nfin=3 l=20n nf=1 m=1
M10_PT SA YSELN[10] BL[10] VDD pmos_rvt nfin=3 l=20n nf=1 m=1
M10_PC SAN YSELN[10] BLN[10] VDD pmos_rvt nfin=3 l=20n nf=1 m=1
M10_PPT BL[10] PRECHN VDD VDD pmos_rvt nfin=3 l=20n nf=1 m=1
M10_PPC BLN[10] PRECHN VDD VDD pmos_rvt nfin=3 l=20n nf=1 m=1
M11_NA YSELN[11] YPA[3] YN[11] VSS nmos_rvt nfin=3 l=20n nf=1 m=1
M11_NB YN[11] YPB[2] VSS VSS nmos_rvt nfin=3 l=20n nf=1 m=1
M11_PA YSELN[11] YPA[3] VDD VDD pmos_rvt nfin=3 l=20n nf=1 m=1
M11_PB YSELN[11] YPB[2] VDD VDD pmos_rvt nfin=3 l=20n nf=1 m=1
M11_NI YSEL[11] YSELN[11] VSS VSS nmos_rvt nfin=3 l=20n nf=1 m=1
M11_PI YSEL[11] YSELN[11] VDD VDD pmos_rvt nfin=3 l=20n nf=1 m=1
M11_NT BL[11] YSEL[11] SA VSS nmos_rvt nfin=3 l=20n nf=1 m=1
M11_NC BLN[11] YSEL[11] SAN VSS nmos_rvt nfin=3 l=20n nf=1 m=1
M11_PT SA YSELN[11] BL[11] VDD pmos_rvt nfin=3 l=20n nf=1 m=1
M11_PC SAN YSELN[11] BLN[11] VDD pmos_rvt nfin=3 l=20n nf=1 m=1
M11_PPT BL[11] PRECHN VDD VDD pmos_rvt nfin=3 l=20n nf=1 m=1
M11_PPC BLN[11] PRECHN VDD VDD pmos_rvt nfin=3 l=20n nf=1 m=1
M12_NA YSELN[12] YPA[0] YN[12] VSS nmos_rvt nfin=3 l=20n nf=1 m=1
M12_NB YN[12] YPB[3] VSS VSS nmos_rvt nfin=3 l=20n nf=1 m=1
M12_PA YSELN[12] YPA[0] VDD VDD pmos_rvt nfin=3 l=20n nf=1 m=1
M12_PB YSELN[12] YPB[3] VDD VDD pmos_rvt nfin=3 l=20n nf=1 m=1
M12_NI YSEL[12] YSELN[12] VSS VSS nmos_rvt nfin=3 l=20n nf=1 m=1
M12_PI YSEL[12] YSELN[12] VDD VDD pmos_rvt nfin=3 l=20n nf=1 m=1
M12_NT BL[12] YSEL[12] SA VSS nmos_rvt nfin=3 l=20n nf=1 m=1
M12_NC BLN[12] YSEL[12] SAN VSS nmos_rvt nfin=3 l=20n nf=1 m=1
M12_PT SA YSELN[12] BL[12] VDD pmos_rvt nfin=3 l=20n nf=1 m=1
M12_PC SAN YSELN[12] BLN[12] VDD pmos_rvt nfin=3 l=20n nf=1 m=1
M12_PPT BL[12] PRECHN VDD VDD pmos_rvt nfin=3 l=20n nf=1 m=1
M12_PPC BLN[12] PRECHN VDD VDD pmos_rvt nfin=3 l=20n nf=1 m=1
M13_NA YSELN[13] YPA[1] YN[13] VSS nmos_rvt nfin=3 l=20n nf=1 m=1
M13_NB YN[13] YPB[3] VSS VSS nmos_rvt nfin=3 l=20n nf=1 m=1
M13_PA YSELN[13] YPA[1] VDD VDD pmos_rvt nfin=3 l=20n nf=1 m=1
M13_PB YSELN[13] YPB[3] VDD VDD pmos_rvt nfin=3 l=20n nf=1 m=1
M13_NI YSEL[13] YSELN[13] VSS VSS nmos_rvt nfin=3 l=20n nf=1 m=1
M13_PI YSEL[13] YSELN[13] VDD VDD pmos_rvt nfin=3 l=20n nf=1 m=1
M13_NT BL[13] YSEL[13] SA VSS nmos_rvt nfin=3 l=20n nf=1 m=1
M13_NC BLN[13] YSEL[13] SAN VSS nmos_rvt nfin=3 l=20n nf=1 m=1
M13_PT SA YSELN[13] BL[13] VDD pmos_rvt nfin=3 l=20n nf=1 m=1
M13_PC SAN YSELN[13] BLN[13] VDD pmos_rvt nfin=3 l=20n nf=1 m=1
M13_PPT BL[13] PRECHN VDD VDD pmos_rvt nfin=3 l=20n nf=1 m=1
M13_PPC BLN[13] PRECHN VDD VDD pmos_rvt nfin=3 l=20n nf=1 m=1
M14_NA YSELN[14] YPA[2] YN[14] VSS nmos_rvt nfin=3 l=20n nf=1 m=1
M14_NB YN[14] YPB[3] VSS VSS nmos_rvt nfin=3 l=20n nf=1 m=1
M14_PA YSELN[14] YPA[2] VDD VDD pmos_rvt nfin=3 l=20n nf=1 m=1
M14_PB YSELN[14] YPB[3] VDD VDD pmos_rvt nfin=3 l=20n nf=1 m=1
M14_NI YSEL[14] YSELN[14] VSS VSS nmos_rvt nfin=3 l=20n nf=1 m=1
M14_PI YSEL[14] YSELN[14] VDD VDD pmos_rvt nfin=3 l=20n nf=1 m=1
M14_NT BL[14] YSEL[14] SA VSS nmos_rvt nfin=3 l=20n nf=1 m=1
M14_NC BLN[14] YSEL[14] SAN VSS nmos_rvt nfin=3 l=20n nf=1 m=1
M14_PT SA YSELN[14] BL[14] VDD pmos_rvt nfin=3 l=20n nf=1 m=1
M14_PC SAN YSELN[14] BLN[14] VDD pmos_rvt nfin=3 l=20n nf=1 m=1
M14_PPT BL[14] PRECHN VDD VDD pmos_rvt nfin=3 l=20n nf=1 m=1
M14_PPC BLN[14] PRECHN VDD VDD pmos_rvt nfin=3 l=20n nf=1 m=1
M15_NA YSELN[15] YPA[3] YN[15] VSS nmos_rvt nfin=3 l=20n nf=1 m=1
M15_NB YN[15] YPB[3] VSS VSS nmos_rvt nfin=3 l=20n nf=1 m=1
M15_PA YSELN[15] YPA[3] VDD VDD pmos_rvt nfin=3 l=20n nf=1 m=1
M15_PB YSELN[15] YPB[3] VDD VDD pmos_rvt nfin=3 l=20n nf=1 m=1
M15_NI YSEL[15] YSELN[15] VSS VSS nmos_rvt nfin=3 l=20n nf=1 m=1
M15_PI YSEL[15] YSELN[15] VDD VDD pmos_rvt nfin=3 l=20n nf=1 m=1
M15_NT BL[15] YSEL[15] SA VSS nmos_rvt nfin=3 l=20n nf=1 m=1
M15_NC BLN[15] YSEL[15] SAN VSS nmos_rvt nfin=3 l=20n nf=1 m=1
M15_PT SA YSELN[15] BL[15] VDD pmos_rvt nfin=3 l=20n nf=1 m=1
M15_PC SAN YSELN[15] BLN[15] VDD pmos_rvt nfin=3 l=20n nf=1 m=1
M15_PPT BL[15] PRECHN VDD VDD pmos_rvt nfin=3 l=20n nf=1 m=1
M15_PPC BLN[15] PRECHN VDD VDD pmos_rvt nfin=3 l=20n nf=1 m=1
Msa_N6_0 sa_N57_0 SA sa_TAIL VSS nmos_rvt nfin=3 l=20n nf=1 m=1
Msa_N8_0 QAN QA sa_N57_0 VSS nmos_rvt nfin=3 l=20n nf=1 m=1
Msa_N7_0 sa_N58_0 SAN sa_TAIL VSS nmos_rvt nfin=3 l=20n nf=1 m=1
Msa_N9_0 QA QAN sa_N58_0 VSS nmos_rvt nfin=3 l=20n nf=1 m=1
Msa_P4_0 QAN QA VDD VDD pmos_rvt nfin=3 l=20n nf=1 m=1
Msa_P5_0 QA QAN VDD VDD pmos_rvt nfin=3 l=20n nf=1 m=1
Msa_N6_1 sa_N57_1 SA sa_TAIL VSS nmos_rvt nfin=3 l=20n nf=1 m=1
Msa_N8_1 QAN QA sa_N57_1 VSS nmos_rvt nfin=3 l=20n nf=1 m=1
Msa_N7_1 sa_N58_1 SAN sa_TAIL VSS nmos_rvt nfin=3 l=20n nf=1 m=1
Msa_N9_1 QA QAN sa_N58_1 VSS nmos_rvt nfin=3 l=20n nf=1 m=1
Msa_P4_1 QAN QA VDD VDD pmos_rvt nfin=3 l=20n nf=1 m=1
Msa_P5_1 QA QAN VDD VDD pmos_rvt nfin=3 l=20n nf=1 m=1
Msa_N10_0 sa_TAIL SAE VSS VSS nmos_rvt nfin=3 l=20n nf=1 m=1
Msa_N10_1 sa_TAIL SAE VSS VSS nmos_rvt nfin=3 l=20n nf=1 m=1
Msa_P0 QAN SAE VDD VDD pmos_rvt nfin=3 l=20n nf=1 m=1
Msa_P1 QAN SAE sa_N59 VDD pmos_rvt nfin=3 l=20n nf=1 m=1
Msa_P2 sa_N59 SAE QA VDD pmos_rvt nfin=3 l=20n nf=1 m=1
Msa_P3 QA SAE VDD VDD pmos_rvt nfin=3 l=20n nf=1 m=1
Mwd_NI wd_DN D VSS VSS nmos_rvt nfin=3 l=20n nf=1 m=1
Mwd_PI wd_DN D VDD VDD pmos_rvt nfin=3 l=20n nf=1 m=1
Mwd_NPD wd_W WRENAN D VSS nmos_rvt nfin=3 l=20n nf=1 m=1
Mwd_NPDN wd_WN WRENAN wd_DN VSS nmos_rvt nfin=3 l=20n nf=1 m=1
Mwd_NW wd_W wd_WN VSS VSS nmos_rvt nfin=3 l=20n nf=1 m=1
Mwd_NWN wd_WN wd_W VSS VSS nmos_rvt nfin=3 l=20n nf=1 m=1
Mwd_PW wd_W wd_WN VDD VDD pmos_rvt nfin=1 l=20n nf=1 m=1
Mwd_PWN wd_WN wd_W VDD VDD pmos_rvt nfin=1 l=20n nf=1 m=1
Mwd_NTW SA WRENA wd_W VSS nmos_rvt nfin=3 l=20n nf=1 m=1
Mwd_PTW SA WRENAN wd_W VDD pmos_rvt nfin=3 l=20n nf=1 m=1
Mwd_NTWN SAN WRENA wd_WN VSS nmos_rvt nfin=3 l=20n nf=1 m=1
Mwd_PTWN SAN WRENAN wd_WN VDD pmos_rvt nfin=3 l=20n nf=1 m=1
Mol_N1A ol_Y1 ol_Y2 ol_M1 VSS nmos_rvt nfin=3 l=20n nf=1 m=1
Mol_N1B ol_M1 QA VSS VSS nmos_rvt nfin=3 l=20n nf=1 m=1
Mol_P1A ol_Y1 ol_Y2 VDD VDD pmos_rvt nfin=3 l=20n nf=1 m=1
Mol_P1B ol_Y1 QA VDD VDD pmos_rvt nfin=3 l=20n nf=1 m=1
Mol_N2A ol_Y2 QAN ol_M2 VSS nmos_rvt nfin=3 l=20n nf=1 m=1
Mol_N2B ol_M2 ol_Y1 VSS VSS nmos_rvt nfin=3 l=20n nf=1 m=1
Mol_P2A ol_Y2 QAN VDD VDD pmos_rvt nfin=3 l=20n nf=1 m=1
Mol_P2B ol_Y2 ol_Y1 VDD VDD pmos_rvt nfin=3 l=20n nf=1 m=1
Mol_NI0 ol_Y2N ol_Y2 VSS VSS nmos_rvt nfin=3 l=20n nf=1 m=1
Mol_NI1 ol_Y2N ol_Y2 VSS VSS nmos_rvt nfin=3 l=20n nf=1 m=1
Mol_PI0 ol_Y2N ol_Y2 VDD VDD pmos_rvt nfin=3 l=20n nf=1 m=1
Mol_PI1 ol_Y2N ol_Y2 VDD VDD pmos_rvt nfin=3 l=20n nf=1 m=1
Mol_NA ol_N2 ol_Y2N VSS VSS nmos_rvt nfin=3 l=20n nf=1 m=1
Mol_NE Q OE ol_N2 VSS nmos_rvt nfin=3 l=20n nf=1 m=1
Mol_PA ol_N1 ol_Y2N VDD VDD pmos_rvt nfin=3 l=20n nf=1 m=1
Mol_PE Q OEB ol_N1 VDD pmos_rvt nfin=3 l=20n nf=1 m=1
.ENDS iocol_block_6t_x16
.SUBCKT iocol_sram_6t_x16 BL_A[0] BLN_A[0] BL_A[1] BLN_A[1] BL_A[2] BLN_A[2] BL_A[3] BLN_A[3] BL_A[4] BLN_A[4] BL_A[5] BLN_A[5] BL_A[6] BLN_A[6] BL_A[7] BLN_A[7] BL_A[8] BLN_A[8] BL_A[9] BLN_A[9] BL_A[10] BLN_A[10] BL_A[11] BLN_A[11] BL_A[12] BLN_A[12] BL_A[13] BLN_A[13] BL_A[14] BLN_A[14] BL_A[15] BLN_A[15] yselA[0] yselA[1] yselA[2] yselA[3] yselA[4] yselA[5] yselA[6] yselA[7] blprechnA sae_A DA wrenaA wrenanA oe_outA oeb_outA QA VDD VSS
X_block BL_A[0] BLN_A[0] BL_A[1] BLN_A[1] BL_A[2] BLN_A[2] BL_A[3] BLN_A[3] BL_A[4] BLN_A[4] BL_A[5] BLN_A[5] BL_A[6] BLN_A[6] BL_A[7] BLN_A[7] BL_A[8] BLN_A[8] BL_A[9] BLN_A[9] BL_A[10] BLN_A[10] BL_A[11] BLN_A[11] BL_A[12] BLN_A[12] BL_A[13] BLN_A[13] BL_A[14] BLN_A[14] BL_A[15] BLN_A[15] yselA[0] yselA[1] yselA[2] yselA[3] yselA[4] yselA[5] yselA[6] yselA[7] blprechnA sae_A DA wrenaA wrenanA oe_outA oeb_outA QA VDD VSS iocol_block_6t_x16
.ENDS iocol_sram_6t_x16
.END
