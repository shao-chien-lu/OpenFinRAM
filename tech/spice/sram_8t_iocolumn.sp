* ASAP7 column IO: bitline mux group, sense amplifier, write driver, output latch
.SUBCKT iocol_block_a BL[0] BLN[0] YSEL[0] YSELN[0] BL[1] BLN[1] YSEL[1] YSELN[1] BL[2] BLN[2] YSEL[2] YSELN[2] BL[3] BLN[3] YSEL[3] YSELN[3] PRECHN SAE D WRENA WRENAN OE OEB Q VDD VSS
M0_NT BL[0] YSEL[0] SA VSS nmos_rvt nfin=6 l=20n nf=1 m=1
M0_NC BLN[0] YSEL[0] SAN VSS nmos_rvt nfin=6 l=20n nf=1 m=1
M0_PT SA YSELN[0] BL[0] VDD pmos_rvt nfin=6 l=20n nf=1 m=1
M0_PC SAN YSELN[0] BLN[0] VDD pmos_rvt nfin=6 l=20n nf=1 m=1
M0_PPT BL[0] PRECHN VDD VDD pmos_rvt nfin=6 l=20n nf=1 m=1
M0_PPC BLN[0] PRECHN VDD VDD pmos_rvt nfin=6 l=20n nf=1 m=1
M1_NT BL[1] YSEL[1] SA VSS nmos_rvt nfin=6 l=20n nf=1 m=1
M1_NC BLN[1] YSEL[1] SAN VSS nmos_rvt nfin=6 l=20n nf=1 m=1
M1_PT SA YSELN[1] BL[1] VDD pmos_rvt nfin=6 l=20n nf=1 m=1
M1_PC SAN YSELN[1] BLN[1] VDD pmos_rvt nfin=6 l=20n nf=1 m=1
M1_PPT BL[1] PRECHN VDD VDD pmos_rvt nfin=6 l=20n nf=1 m=1
M1_PPC BLN[1] PRECHN VDD VDD pmos_rvt nfin=6 l=20n nf=1 m=1
M2_NT BL[2] YSEL[2] SA VSS nmos_rvt nfin=6 l=20n nf=1 m=1
M2_NC BLN[2] YSEL[2] SAN VSS nmos_rvt nfin=6 l=20n nf=1 m=1
M2_PT SA YSELN[2] BL[2] VDD pmos_rvt nfin=6 l=20n nf=1 m=1
M2_PC SAN YSELN[2] BLN[2] VDD pmos_rvt nfin=6 l=20n nf=1 m=1
M2_PPT BL[2] PRECHN VDD VDD pmos_rvt nfin=6 l=20n nf=1 m=1
M2_PPC BLN[2] PRECHN VDD VDD pmos_rvt nfin=6 l=20n nf=1 m=1
M3_NT BL[3] YSEL[3] SA VSS nmos_rvt nfin=6 l=20n nf=1 m=1
M3_NC BLN[3] YSEL[3] SAN VSS nmos_rvt nfin=6 l=20n nf=1 m=1
M3_PT SA YSELN[3] BL[3] VDD pmos_rvt nfin=6 l=20n nf=1 m=1
M3_PC SAN YSELN[3] BLN[3] VDD pmos_rvt nfin=6 l=20n nf=1 m=1
M3_PPT BL[3] PRECHN VDD VDD pmos_rvt nfin=6 l=20n nf=1 m=1
M3_PPC BLN[3] PRECHN VDD VDD pmos_rvt nfin=6 l=20n nf=1 m=1
Msa_N6_0 sa_N57_0 SA sa_TAIL VSS nmos_rvt nfin=3 l=20n nf=1 m=1
Msa_N8_0 QAN QA sa_N57_0 VSS nmos_rvt nfin=3 l=20n nf=1 m=1
Msa_N7_0 sa_N58_0 SAN sa_TAIL VSS nmos_rvt nfin=3 l=20n nf=1 m=1
Msa_N9_0 QA QAN sa_N58_0 VSS nmos_rvt nfin=3 l=20n nf=1 m=1
Msa_P4_0 QAN QA VDD VDD pmos_rvt nfin=3 l=20n nf=1 m=1
Msa_P5_0 QA QAN VDD VDD pmos_rvt nfin=3 l=20n nf=1 m=1
Msa_N6_1 sa_N57_1 SA sa_TAIL VSS nmos_rvt nfin=3 l=20n nf=1 m=1
Msa_N8_1 QAN QA sa_N57_1 VSS nmos_rvt nfin=3 l=20n nf=1 m=1
Msa_N7_1 sa_N58_1 SAN sa_TAIL VSS nmos_rvt nfin=3 l=20n nf=1 m=1
Msa_N9_1 QA QAN sa_N58_1 VSS nmos_rvt nfin=3 l=20n nf=1 m=1
Msa_P4_1 QAN QA VDD VDD pmos_rvt nfin=3 l=20n nf=1 m=1
Msa_P5_1 QA QAN VDD VDD pmos_rvt nfin=3 l=20n nf=1 m=1
Msa_N10_0 sa_TAIL SAE VSS VSS nmos_rvt nfin=3 l=20n nf=1 m=1
Msa_N10_1 sa_TAIL SAE VSS VSS nmos_rvt nfin=3 l=20n nf=1 m=1
Msa_P0 QAN SAE VDD VDD pmos_rvt nfin=3 l=20n nf=1 m=1
Msa_P1 QAN SAE sa_N59 VDD pmos_rvt nfin=3 l=20n nf=1 m=1
Msa_P2 sa_N59 SAE QA VDD pmos_rvt nfin=3 l=20n nf=1 m=1
Msa_P3 QA SAE VDD VDD pmos_rvt nfin=3 l=20n nf=1 m=1
Mwd_NI wd_DN D VSS VSS nmos_rvt nfin=3 l=20n nf=1 m=1
Mwd_PI wd_DN D VDD VDD pmos_rvt nfin=3 l=20n nf=1 m=1
Mwd_NPD wd_W WRENAN D VSS nmos_rvt nfin=3 l=20n nf=1 m=1
Mwd_NPDN wd_WN WRENAN wd_DN VSS nmos_rvt nfin=3 l=20n nf=1 m=1
Mwd_NW wd_W wd_WN VSS VSS nmos_rvt nfin=3 l=20n nf=1 m=1
Mwd_NWN wd_WN wd_W VSS VSS nmos_rvt nfin=3 l=20n nf=1 m=1
Mwd_PW wd_W wd_WN VDD VDD pmos_rvt nfin=1 l=20n nf=1 m=1
Mwd_PWN wd_WN wd_W VDD VDD pmos_rvt nfin=1 l=20n nf=1 m=1
Mwd_NTW SA WRENA wd_W VSS nmos_rvt nfin=3 l=20n nf=1 m=1
Mwd_PTW SA WRENAN wd_W VDD pmos_rvt nfin=3 l=20n nf=1 m=1
Mwd_NTWN SAN WRENA wd_WN VSS nmos_rvt nfin=3 l=20n nf=1 m=1
Mwd_PTWN SAN WRENAN wd_WN VDD pmos_rvt nfin=3 l=20n nf=1 m=1
Mol_N1A ol_Y1 ol_Y2 ol_M1 VSS nmos_rvt nfin=3 l=20n nf=1 m=1
Mol_N1B ol_M1 QA VSS VSS nmos_rvt nfin=3 l=20n nf=1 m=1
Mol_P1A ol_Y1 ol_Y2 VDD VDD pmos_rvt nfin=3 l=20n nf=1 m=1
Mol_P1B ol_Y1 QA VDD VDD pmos_rvt nfin=3 l=20n nf=1 m=1
Mol_N2A ol_M2 QAN VSS VSS nmos_rvt nfin=3 l=20n nf=1 m=1
Mol_N2B ol_Y2 ol_Y1 ol_M2 VSS nmos_rvt nfin=3 l=20n nf=1 m=1
Mol_P2A ol_Y2 QAN VDD VDD pmos_rvt nfin=3 l=20n nf=1 m=1
Mol_P2B ol_Y2 ol_Y1 VDD VDD pmos_rvt nfin=3 l=20n nf=1 m=1
Mol_NI ol_Y2N ol_Y2 VSS VSS nmos_rvt nfin=3 l=20n nf=1 m=1
Mol_PI ol_Y2N ol_Y2 VDD VDD pmos_rvt nfin=3 l=20n nf=1 m=1
Mol_NA0 ol_N2_0 ol_Y2N VSS VSS nmos_rvt nfin=3 l=20n nf=1 m=1
Mol_NE0 Q OE ol_N2_0 VSS nmos_rvt nfin=3 l=20n nf=1 m=1
Mol_PA0 ol_N1_0 ol_Y2N VDD VDD pmos_rvt nfin=3 l=20n nf=1 m=1
Mol_PE0 Q OEB ol_N1_0 VDD pmos_rvt nfin=3 l=20n nf=1 m=1
Mol_NA1 ol_N2_1 ol_Y2N VSS VSS nmos_rvt nfin=3 l=20n nf=1 m=1
Mol_NE1 Q OE ol_N2_1 VSS nmos_rvt nfin=3 l=20n nf=1 m=1
Mol_PA1 ol_N1_1 ol_Y2N VDD VDD pmos_rvt nfin=3 l=20n nf=1 m=1
Mol_PE1 Q OEB ol_N1_1 VDD pmos_rvt nfin=3 l=20n nf=1 m=1
.ENDS iocol_block_a

.SUBCKT iocol_sram_8t_a BL_A[0] BL_A[1] BL_A[2] BL_A[3] BLN_A[0] BLN_A[1] BLN_A[2] BLN_A[3] ysel_A[0] ysel_A[1] ysel_A[2] ysel_A[3] yseln_A[0] yseln_A[1] yseln_A[2] yseln_A[3] blprechn_A sae_A wrena_A wrenan_A oe_out_A oeb_out_A DA QA VDD VSS
X_block BL_A[0] BLN_A[0] ysel_A[0] yseln_A[0] BL_A[1] BLN_A[1] ysel_A[1] yseln_A[1] BL_A[2] BLN_A[2] ysel_A[2] yseln_A[2] BL_A[3] BLN_A[3] ysel_A[3] yseln_A[3] blprechn_A sae_A DA wrena_A wrenan_A oe_out_A oeb_out_A QA VDD VSS iocol_block_a
.ENDS iocol_sram_8t_a

* ASAP7 column IO: bitline mux group, sense amplifier, write driver, output latch
.SUBCKT iocol_block_b BL[0] BLN[0] YSEL[0] YSELN[0] BL[1] BLN[1] YSEL[1] YSELN[1] BL[2] BLN[2] YSEL[2] YSELN[2] BL[3] BLN[3] YSEL[3] YSELN[3] PRECHN SAE D WRENA WRENAN OE OEB Q VDD VSS
M0_NT BL[0] YSEL[0] SA VSS nmos_rvt nfin=6 l=20n nf=1 m=1
M0_NC BLN[0] YSEL[0] SAN VSS nmos_rvt nfin=6 l=20n nf=1 m=1
M0_PT SA YSELN[0] BL[0] VDD pmos_rvt nfin=6 l=20n nf=1 m=1
M0_PC SAN YSELN[0] BLN[0] VDD pmos_rvt nfin=6 l=20n nf=1 m=1
M0_PPT BL[0] PRECHN VDD VDD pmos_rvt nfin=6 l=20n nf=1 m=1
M0_PPC BLN[0] PRECHN VDD VDD pmos_rvt nfin=6 l=20n nf=1 m=1
M1_NT BL[1] YSEL[1] SA VSS nmos_rvt nfin=6 l=20n nf=1 m=1
M1_NC BLN[1] YSEL[1] SAN VSS nmos_rvt nfin=6 l=20n nf=1 m=1
M1_PT SA YSELN[1] BL[1] VDD pmos_rvt nfin=6 l=20n nf=1 m=1
M1_PC SAN YSELN[1] BLN[1] VDD pmos_rvt nfin=6 l=20n nf=1 m=1
M1_PPT BL[1] PRECHN VDD VDD pmos_rvt nfin=6 l=20n nf=1 m=1
M1_PPC BLN[1] PRECHN VDD VDD pmos_rvt nfin=6 l=20n nf=1 m=1
M2_NT BL[2] YSEL[2] SA VSS nmos_rvt nfin=6 l=20n nf=1 m=1
M2_NC BLN[2] YSEL[2] SAN VSS nmos_rvt nfin=6 l=20n nf=1 m=1
M2_PT SA YSELN[2] BL[2] VDD pmos_rvt nfin=6 l=20n nf=1 m=1
M2_PC SAN YSELN[2] BLN[2] VDD pmos_rvt nfin=6 l=20n nf=1 m=1
M2_PPT BL[2] PRECHN VDD VDD pmos_rvt nfin=6 l=20n nf=1 m=1
M2_PPC BLN[2] PRECHN VDD VDD pmos_rvt nfin=6 l=20n nf=1 m=1
M3_NT BL[3] YSEL[3] SA VSS nmos_rvt nfin=6 l=20n nf=1 m=1
M3_NC BLN[3] YSEL[3] SAN VSS nmos_rvt nfin=6 l=20n nf=1 m=1
M3_PT SA YSELN[3] BL[3] VDD pmos_rvt nfin=6 l=20n nf=1 m=1
M3_PC SAN YSELN[3] BLN[3] VDD pmos_rvt nfin=6 l=20n nf=1 m=1
M3_PPT BL[3] PRECHN VDD VDD pmos_rvt nfin=6 l=20n nf=1 m=1
M3_PPC BLN[3] PRECHN VDD VDD pmos_rvt nfin=6 l=20n nf=1 m=1
Msa_N6_0 sa_N57_0 SA sa_TAIL VSS nmos_rvt nfin=3 l=20n nf=1 m=1
Msa_N8_0 QAN QA sa_N57_0 VSS nmos_rvt nfin=3 l=20n nf=1 m=1
Msa_N7_0 sa_N58_0 SAN sa_TAIL VSS nmos_rvt nfin=3 l=20n nf=1 m=1
Msa_N9_0 QA QAN sa_N58_0 VSS nmos_rvt nfin=3 l=20n nf=1 m=1
Msa_P4_0 QAN QA VDD VDD pmos_rvt nfin=3 l=20n nf=1 m=1
Msa_P5_0 QA QAN VDD VDD pmos_rvt nfin=3 l=20n nf=1 m=1
Msa_N6_1 sa_N57_1 SA sa_TAIL VSS nmos_rvt nfin=3 l=20n nf=1 m=1
Msa_N8_1 QAN QA sa_N57_1 VSS nmos_rvt nfin=3 l=20n nf=1 m=1
Msa_N7_1 sa_N58_1 SAN sa_TAIL VSS nmos_rvt nfin=3 l=20n nf=1 m=1
Msa_N9_1 QA QAN sa_N58_1 VSS nmos_rvt nfin=3 l=20n nf=1 m=1
Msa_P4_1 QAN QA VDD VDD pmos_rvt nfin=3 l=20n nf=1 m=1
Msa_P5_1 QA QAN VDD VDD pmos_rvt nfin=3 l=20n nf=1 m=1
Msa_N10_0 sa_TAIL SAE VSS VSS nmos_rvt nfin=3 l=20n nf=1 m=1
Msa_N10_1 sa_TAIL SAE VSS VSS nmos_rvt nfin=3 l=20n nf=1 m=1
Msa_P0 QAN SAE VDD VDD pmos_rvt nfin=3 l=20n nf=1 m=1
Msa_P1 QAN SAE sa_N59 VDD pmos_rvt nfin=3 l=20n nf=1 m=1
Msa_P2 sa_N59 SAE QA VDD pmos_rvt nfin=3 l=20n nf=1 m=1
Msa_P3 QA SAE VDD VDD pmos_rvt nfin=3 l=20n nf=1 m=1
Mwd_NI wd_DN D VSS VSS nmos_rvt nfin=3 l=20n nf=1 m=1
Mwd_PI wd_DN D VDD VDD pmos_rvt nfin=3 l=20n nf=1 m=1
Mwd_NPD wd_W WRENAN D VSS nmos_rvt nfin=3 l=20n nf=1 m=1
Mwd_NPDN wd_WN WRENAN wd_DN VSS nmos_rvt nfin=3 l=20n nf=1 m=1
Mwd_NW wd_W wd_WN VSS VSS nmos_rvt nfin=3 l=20n nf=1 m=1
Mwd_NWN wd_WN wd_W VSS VSS nmos_rvt nfin=3 l=20n nf=1 m=1
Mwd_PW wd_W wd_WN VDD VDD pmos_rvt nfin=1 l=20n nf=1 m=1
Mwd_PWN wd_WN wd_W VDD VDD pmos_rvt nfin=1 l=20n nf=1 m=1
Mwd_NTW SA WRENA wd_W VSS nmos_rvt nfin=3 l=20n nf=1 m=1
Mwd_PTW SA WRENAN wd_W VDD pmos_rvt nfin=3 l=20n nf=1 m=1
Mwd_NTWN SAN WRENA wd_WN VSS nmos_rvt nfin=3 l=20n nf=1 m=1
Mwd_PTWN SAN WRENAN wd_WN VDD pmos_rvt nfin=3 l=20n nf=1 m=1
Mol_N1A ol_Y1 ol_Y2 ol_M1 VSS nmos_rvt nfin=3 l=20n nf=1 m=1
Mol_N1B ol_M1 QA VSS VSS nmos_rvt nfin=3 l=20n nf=1 m=1
Mol_P1A ol_Y1 ol_Y2 VDD VDD pmos_rvt nfin=3 l=20n nf=1 m=1
Mol_P1B ol_Y1 QA VDD VDD pmos_rvt nfin=3 l=20n nf=1 m=1
Mol_N2A ol_M2 QAN VSS VSS nmos_rvt nfin=3 l=20n nf=1 m=1
Mol_N2B ol_Y2 ol_Y1 ol_M2 VSS nmos_rvt nfin=3 l=20n nf=1 m=1
Mol_P2A ol_Y2 QAN VDD VDD pmos_rvt nfin=3 l=20n nf=1 m=1
Mol_P2B ol_Y2 ol_Y1 VDD VDD pmos_rvt nfin=3 l=20n nf=1 m=1
Mol_NI ol_Y2N ol_Y2 VSS VSS nmos_rvt nfin=3 l=20n nf=1 m=1
Mol_PI ol_Y2N ol_Y2 VDD VDD pmos_rvt nfin=3 l=20n nf=1 m=1
Mol_NA0 ol_N2_0 ol_Y2N VSS VSS nmos_rvt nfin=3 l=20n nf=1 m=1
Mol_NE0 Q OE ol_N2_0 VSS nmos_rvt nfin=3 l=20n nf=1 m=1
Mol_PA0 ol_N1_0 ol_Y2N VDD VDD pmos_rvt nfin=3 l=20n nf=1 m=1
Mol_PE0 Q OEB ol_N1_0 VDD pmos_rvt nfin=3 l=20n nf=1 m=1
Mol_NA1 ol_N2_1 ol_Y2N VSS VSS nmos_rvt nfin=3 l=20n nf=1 m=1
Mol_NE1 Q OE ol_N2_1 VSS nmos_rvt nfin=3 l=20n nf=1 m=1
Mol_PA1 ol_N1_1 ol_Y2N VDD VDD pmos_rvt nfin=3 l=20n nf=1 m=1
Mol_PE1 Q OEB ol_N1_1 VDD pmos_rvt nfin=3 l=20n nf=1 m=1
.ENDS iocol_block_b

.SUBCKT iocol_sram_8t_b BL_B[0] BL_B[1] BL_B[2] BL_B[3] BLN_B[0] BLN_B[1] BLN_B[2] BLN_B[3] ysel_B[0] ysel_B[1] ysel_B[2] ysel_B[3] yseln_B[0] yseln_B[1] yseln_B[2] yseln_B[3] blprechn_B sae_B wrena_B wrenan_B oe_out_B oeb_out_B DB QB VDD VSS
X_block BL_B[0] BLN_B[0] ysel_B[0] yseln_B[0] BL_B[1] BLN_B[1] ysel_B[1] yseln_B[1] BL_B[2] BLN_B[2] ysel_B[2] yseln_B[2] BL_B[3] BLN_B[3] ysel_B[3] yseln_B[3] blprechn_B sae_B DB wrena_B wrenan_B oe_out_B oeb_out_B QB VDD VSS iocol_block_b
.ENDS iocol_sram_8t_b

* ASAP7 column IO: bitline mux group, sense amplifier, write driver, output latch
.SUBCKT iocol_block_b2 BL[0] BLN[0] YSEL[0] YSELN[0] BL[1] BLN[1] YSEL[1] YSELN[1] BL[2] BLN[2] YSEL[2] YSELN[2] BL[3] BLN[3] YSEL[3] YSELN[3] PRECHN BL_R[0] BLN_R[0] YSEL_R[0] YSELN_R[0] BL_R[1] BLN_R[1] YSEL_R[1] YSELN_R[1] BL_R[2] BLN_R[2] YSEL_R[2] YSELN_R[2] BL_R[3] BLN_R[3] YSEL_R[3] YSELN_R[3] PRECHN_R SAE D WRENA WRENAN OE OEB Q VDD VSS
M0_NT BL[0] YSEL[0] SA VSS nmos_rvt nfin=6 l=20n nf=1 m=1
M0R_NT BL_R[0] YSEL_R[0] SA VSS nmos_rvt nfin=6 l=20n nf=1 m=1
M0_NC BLN[0] YSEL[0] SAN VSS nmos_rvt nfin=6 l=20n nf=1 m=1
M0R_NC BLN_R[0] YSEL_R[0] SAN VSS nmos_rvt nfin=6 l=20n nf=1 m=1
M0_PT SA YSELN[0] BL[0] VDD pmos_rvt nfin=6 l=20n nf=1 m=1
M0R_PT SA YSELN_R[0] BL_R[0] VDD pmos_rvt nfin=6 l=20n nf=1 m=1
M0_PC SAN YSELN[0] BLN[0] VDD pmos_rvt nfin=6 l=20n nf=1 m=1
M0R_PC SAN YSELN_R[0] BLN_R[0] VDD pmos_rvt nfin=6 l=20n nf=1 m=1
M0_PPT BL[0] PRECHN VDD VDD pmos_rvt nfin=6 l=20n nf=1 m=1
M0R_PPT BL_R[0] PRECHN_R VDD VDD pmos_rvt nfin=6 l=20n nf=1 m=1
M0_PPC BLN[0] PRECHN VDD VDD pmos_rvt nfin=6 l=20n nf=1 m=1
M0R_PPC BLN_R[0] PRECHN_R VDD VDD pmos_rvt nfin=6 l=20n nf=1 m=1
M1_NT BL[1] YSEL[1] SA VSS nmos_rvt nfin=6 l=20n nf=1 m=1
M1R_NT BL_R[1] YSEL_R[1] SA VSS nmos_rvt nfin=6 l=20n nf=1 m=1
M1_NC BLN[1] YSEL[1] SAN VSS nmos_rvt nfin=6 l=20n nf=1 m=1
M1R_NC BLN_R[1] YSEL_R[1] SAN VSS nmos_rvt nfin=6 l=20n nf=1 m=1
M1_PT SA YSELN[1] BL[1] VDD pmos_rvt nfin=6 l=20n nf=1 m=1
M1R_PT SA YSELN_R[1] BL_R[1] VDD pmos_rvt nfin=6 l=20n nf=1 m=1
M1_PC SAN YSELN[1] BLN[1] VDD pmos_rvt nfin=6 l=20n nf=1 m=1
M1R_PC SAN YSELN_R[1] BLN_R[1] VDD pmos_rvt nfin=6 l=20n nf=1 m=1
M1_PPT BL[1] PRECHN VDD VDD pmos_rvt nfin=6 l=20n nf=1 m=1
M1R_PPT BL_R[1] PRECHN_R VDD VDD pmos_rvt nfin=6 l=20n nf=1 m=1
M1_PPC BLN[1] PRECHN VDD VDD pmos_rvt nfin=6 l=20n nf=1 m=1
M1R_PPC BLN_R[1] PRECHN_R VDD VDD pmos_rvt nfin=6 l=20n nf=1 m=1
M2_NT BL[2] YSEL[2] SA VSS nmos_rvt nfin=6 l=20n nf=1 m=1
M2R_NT BL_R[2] YSEL_R[2] SA VSS nmos_rvt nfin=6 l=20n nf=1 m=1
M2_NC BLN[2] YSEL[2] SAN VSS nmos_rvt nfin=6 l=20n nf=1 m=1
M2R_NC BLN_R[2] YSEL_R[2] SAN VSS nmos_rvt nfin=6 l=20n nf=1 m=1
M2_PT SA YSELN[2] BL[2] VDD pmos_rvt nfin=6 l=20n nf=1 m=1
M2R_PT SA YSELN_R[2] BL_R[2] VDD pmos_rvt nfin=6 l=20n nf=1 m=1
M2_PC SAN YSELN[2] BLN[2] VDD pmos_rvt nfin=6 l=20n nf=1 m=1
M2R_PC SAN YSELN_R[2] BLN_R[2] VDD pmos_rvt nfin=6 l=20n nf=1 m=1
M2_PPT BL[2] PRECHN VDD VDD pmos_rvt nfin=6 l=20n nf=1 m=1
M2R_PPT BL_R[2] PRECHN_R VDD VDD pmos_rvt nfin=6 l=20n nf=1 m=1
M2_PPC BLN[2] PRECHN VDD VDD pmos_rvt nfin=6 l=20n nf=1 m=1
M2R_PPC BLN_R[2] PRECHN_R VDD VDD pmos_rvt nfin=6 l=20n nf=1 m=1
M3_NT BL[3] YSEL[3] SA VSS nmos_rvt nfin=6 l=20n nf=1 m=1
M3R_NT BL_R[3] YSEL_R[3] SA VSS nmos_rvt nfin=6 l=20n nf=1 m=1
M3_NC BLN[3] YSEL[3] SAN VSS nmos_rvt nfin=6 l=20n nf=1 m=1
M3R_NC BLN_R[3] YSEL_R[3] SAN VSS nmos_rvt nfin=6 l=20n nf=1 m=1
M3_PT SA YSELN[3] BL[3] VDD pmos_rvt nfin=6 l=20n nf=1 m=1
M3R_PT SA YSELN_R[3] BL_R[3] VDD pmos_rvt nfin=6 l=20n nf=1 m=1
M3_PC SAN YSELN[3] BLN[3] VDD pmos_rvt nfin=6 l=20n nf=1 m=1
M3R_PC SAN YSELN_R[3] BLN_R[3] VDD pmos_rvt nfin=6 l=20n nf=1 m=1
M3_PPT BL[3] PRECHN VDD VDD pmos_rvt nfin=6 l=20n nf=1 m=1
M3R_PPT BL_R[3] PRECHN_R VDD VDD pmos_rvt nfin=6 l=20n nf=1 m=1
M3_PPC BLN[3] PRECHN VDD VDD pmos_rvt nfin=6 l=20n nf=1 m=1
M3R_PPC BLN_R[3] PRECHN_R VDD VDD pmos_rvt nfin=6 l=20n nf=1 m=1
Msa_N6_0 sa_N57_0 SA sa_TAIL VSS nmos_rvt nfin=3 l=20n nf=1 m=1
Msa_N8_0 QAN QA sa_N57_0 VSS nmos_rvt nfin=3 l=20n nf=1 m=1
Msa_N7_0 sa_N58_0 SAN sa_TAIL VSS nmos_rvt nfin=3 l=20n nf=1 m=1
Msa_N9_0 QA QAN sa_N58_0 VSS nmos_rvt nfin=3 l=20n nf=1 m=1
Msa_P4_0 QAN QA VDD VDD pmos_rvt nfin=3 l=20n nf=1 m=1
Msa_P5_0 QA QAN VDD VDD pmos_rvt nfin=3 l=20n nf=1 m=1
Msa_N6_1 sa_N57_1 SA sa_TAIL VSS nmos_rvt nfin=3 l=20n nf=1 m=1
Msa_N8_1 QAN QA sa_N57_1 VSS nmos_rvt nfin=3 l=20n nf=1 m=1
Msa_N7_1 sa_N58_1 SAN sa_TAIL VSS nmos_rvt nfin=3 l=20n nf=1 m=1
Msa_N9_1 QA QAN sa_N58_1 VSS nmos_rvt nfin=3 l=20n nf=1 m=1
Msa_P4_1 QAN QA VDD VDD pmos_rvt nfin=3 l=20n nf=1 m=1
Msa_P5_1 QA QAN VDD VDD pmos_rvt nfin=3 l=20n nf=1 m=1
Msa_N10_0 sa_TAIL SAE VSS VSS nmos_rvt nfin=3 l=20n nf=1 m=1
Msa_N10_1 sa_TAIL SAE VSS VSS nmos_rvt nfin=3 l=20n nf=1 m=1
Msa_P0 QAN SAE VDD VDD pmos_rvt nfin=3 l=20n nf=1 m=1
Msa_P1 QAN SAE sa_N59 VDD pmos_rvt nfin=3 l=20n nf=1 m=1
Msa_P2 sa_N59 SAE QA VDD pmos_rvt nfin=3 l=20n nf=1 m=1
Msa_P3 QA SAE VDD VDD pmos_rvt nfin=3 l=20n nf=1 m=1
Mwd_NI wd_DN D VSS VSS nmos_rvt nfin=3 l=20n nf=1 m=1
Mwd_PI wd_DN D VDD VDD pmos_rvt nfin=3 l=20n nf=1 m=1
Mwd_NPD wd_W WRENAN D VSS nmos_rvt nfin=3 l=20n nf=1 m=1
Mwd_NPDN wd_WN WRENAN wd_DN VSS nmos_rvt nfin=3 l=20n nf=1 m=1
Mwd_NW wd_W wd_WN VSS VSS nmos_rvt nfin=3 l=20n nf=1 m=1
Mwd_NWN wd_WN wd_W VSS VSS nmos_rvt nfin=3 l=20n nf=1 m=1
Mwd_PW wd_W wd_WN VDD VDD pmos_rvt nfin=1 l=20n nf=1 m=1
Mwd_PWN wd_WN wd_W VDD VDD pmos_rvt nfin=1 l=20n nf=1 m=1
Mwd_NTW SA WRENA wd_W VSS nmos_rvt nfin=3 l=20n nf=1 m=1
Mwd_PTW SA WRENAN wd_W VDD pmos_rvt nfin=3 l=20n nf=1 m=1
Mwd_NTWN SAN WRENA wd_WN VSS nmos_rvt nfin=3 l=20n nf=1 m=1
Mwd_PTWN SAN WRENAN wd_WN VDD pmos_rvt nfin=3 l=20n nf=1 m=1
Mol_N1A ol_Y1 ol_Y2 ol_M1 VSS nmos_rvt nfin=3 l=20n nf=1 m=1
Mol_N1B ol_M1 QA VSS VSS nmos_rvt nfin=3 l=20n nf=1 m=1
Mol_P1A ol_Y1 ol_Y2 VDD VDD pmos_rvt nfin=3 l=20n nf=1 m=1
Mol_P1B ol_Y1 QA VDD VDD pmos_rvt nfin=3 l=20n nf=1 m=1
Mol_N2A ol_M2 QAN VSS VSS nmos_rvt nfin=3 l=20n nf=1 m=1
Mol_N2B ol_Y2 ol_Y1 ol_M2 VSS nmos_rvt nfin=3 l=20n nf=1 m=1
Mol_P2A ol_Y2 QAN VDD VDD pmos_rvt nfin=3 l=20n nf=1 m=1
Mol_P2B ol_Y2 ol_Y1 VDD VDD pmos_rvt nfin=3 l=20n nf=1 m=1
Mol_NI ol_Y2N ol_Y2 VSS VSS nmos_rvt nfin=3 l=20n nf=1 m=1
Mol_PI ol_Y2N ol_Y2 VDD VDD pmos_rvt nfin=3 l=20n nf=1 m=1
Mol_NA0 ol_N2_0 ol_Y2N VSS VSS nmos_rvt nfin=3 l=20n nf=1 m=1
Mol_NE0 Q OE ol_N2_0 VSS nmos_rvt nfin=3 l=20n nf=1 m=1
Mol_PA0 ol_N1_0 ol_Y2N VDD VDD pmos_rvt nfin=3 l=20n nf=1 m=1
Mol_PE0 Q OEB ol_N1_0 VDD pmos_rvt nfin=3 l=20n nf=1 m=1
Mol_NA1 ol_N2_1 ol_Y2N VSS VSS nmos_rvt nfin=3 l=20n nf=1 m=1
Mol_NE1 Q OE ol_N2_1 VSS nmos_rvt nfin=3 l=20n nf=1 m=1
Mol_PA1 ol_N1_1 ol_Y2N VDD VDD pmos_rvt nfin=3 l=20n nf=1 m=1
Mol_PE1 Q OEB ol_N1_1 VDD pmos_rvt nfin=3 l=20n nf=1 m=1
.ENDS iocol_block_b2

.SUBCKT iocol_sram_8t_b2 BL_B[0] BL_B[1] BL_B[2] BL_B[3] BL_B[4] BL_B[5] BL_B[6] BL_B[7] BLN_B[0] BLN_B[1] BLN_B[2] BLN_B[3] BLN_B[4] BLN_B[5] BLN_B[6] BLN_B[7] ysel_B[0] ysel_B[1] ysel_B[2] ysel_B[3] ysel_B[4] ysel_B[5] ysel_B[6] ysel_B[7] yseln_B[0] yseln_B[1] yseln_B[2] yseln_B[3] yseln_B[4] yseln_B[5] yseln_B[6] yseln_B[7] blprechn_B blprechn_BR sae_B wrena_B wrenan_B oe_out_B oeb_out_B DB QB VDD VSS
X_block BL_B[0] BLN_B[0] ysel_B[0] yseln_B[0] BL_B[1] BLN_B[1] ysel_B[1] yseln_B[1] BL_B[2] BLN_B[2] ysel_B[2] yseln_B[2] BL_B[3] BLN_B[3] ysel_B[3] yseln_B[3] blprechn_B BL_B[4] BLN_B[4] ysel_B[4] yseln_B[4] BL_B[5] BLN_B[5] ysel_B[5] yseln_B[5] BL_B[6] BLN_B[6] ysel_B[6] yseln_B[6] BL_B[7] BLN_B[7] ysel_B[7] yseln_B[7] blprechn_BR sae_B DB wrena_B wrenan_B oe_out_B oeb_out_B QB VDD VSS iocol_block_b2
.ENDS iocol_sram_8t_b2
.END
